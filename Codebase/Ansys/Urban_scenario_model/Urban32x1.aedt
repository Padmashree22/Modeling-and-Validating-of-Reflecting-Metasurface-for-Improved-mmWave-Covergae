# Ansys Electronics Desktop project, version 2021.2
materials:
  vacuum: permittivity=1
  pec: conductivity=1e+30

design HFSSDesign1 (HFSS, SBR+, model units mm)
variables:
  alpha11 = 0.2deg
  Length = k/32
  Width = k
  beta = 0.1deg
  alpha12 = alpha11
  alpha13 = alpha11+delta
  alpha14 = alpha11+delta
  alpha15 = alpha11+ delta
  alpha16 = alpha11+ delta
  alpha17 = alpha11+ 2*delta
  alpha18 = alpha11+ 2*delta
  alpha19 = alpha11+ 2*delta
  alpha110 = alpha11+ 2*delta
  alpha111 = alpha11+ 2*delta
  alpha112 = alpha11+ 3*delta
  alpha113 = alpha11+ 3*delta
  alpha114 = alpha11+ 3*delta
  alpha115 = alpha11+ 3*delta
  alpha116 = alpha11+ 3*delta
  alpha117 = alpha11+ 3*delta
  alpha118 = alpha11+ 4*delta
  alpha119 = alpha11+ 4*delta
  alpha120 = alpha11+ 4*delta
  alpha121 = alpha11+ 4*delta
  alpha122 = alpha11+ 4*delta
  alpha123 = alpha11+ 4*delta
  alpha124 = alpha11+ 5*delta
  alpha125 = alpha11+ 5*delta
  alpha126 = alpha11+ 5*delta
  alpha127 = alpha11+ 5*delta
  alpha128 = alpha11+ 5*delta
  alpha129 = alpha11+ 6*delta
  alpha130 = alpha11+ 6*delta
  alpha131 = alpha11+ 6*delta
  alpha132 = alpha11+ 6*delta
  spacing_magnitude = 1meter
  el_angle = 90deg
  az_angle = 0deg
  spacing_x = spacing_magnitude*sin(el_angle*pi/180 deg)*cos(az_angle*pi/180 deg)
  spacing_y = spacing_magnitude*sin(el_angle*pi/180 deg)*sin(-1*az_angle*pi/180 deg)
  spacing_z = spacing_magnitude*cos(el_angle*pi/180 deg)
  delta = 0deg
  k = 3meter
geometry:
  coordinate_system Module11 = origin=(0mm, 0mm, 0mm) x=(1mm, 0mm, 0mm) y=(0mm, 1mm, 0mm)
  HFSSDesign1_1 = component(HFSSDesign1, 3D_Component_File_Path=C:/Users/vemana/Desktop/alphabeta_HELIOS_Footprint.a3dcomp, alpha=alpha11, dz=Width, beta=beta, dy=Length)
  Reflector_Element [copper] = part_of(HFSSDesign1_1) in Module11
  coordinate_system Module12 = origin=(0mm, Length, 0mm) x=(1mm, 0mm, 0mm) y=(0mm, 1mm, 0mm)
  coordinate_system Module13 = origin=(0mm, 2*Length, 0mm) x=(1mm, 0mm, 0mm) y=(0mm, 1mm, 0mm)
  coordinate_system Module14 = origin=(0mm, 3*Length, 0mm) x=(1mm, 0mm, 0mm) y=(0mm, 1mm, 0mm)
  coordinate_system Module15 = origin=(0mm, 4*Length, 0mm) x=(1mm, 0mm, 0mm) y=(0mm, 1mm, 0mm)
  coordinate_system Module16 = origin=(0mm, 5*Length, 0mm) x=(1mm, 0mm, 0mm) y=(0mm, 1mm, 0mm)
  coordinate_system Module17 = origin=(0mm, 6*Length, 0mm) x=(1mm, 0mm, 0mm) y=(0mm, 1mm, 0mm)
  coordinate_system Module18 = origin=(0mm, 7*Length, 0mm) x=(1mm, 0mm, 0mm) y=(0mm, 1mm, 0mm)
  coordinate_system Module19 = origin=(0mm, 8*Length, 0mm) x=(1mm, 0mm, 0mm) y=(0mm, 1mm, 0mm)
  coordinate_system Module110 = origin=(0mm, 9*Length, 0mm) x=(1mm, 0mm, 0mm) y=(0mm, 1mm, 0mm)
  coordinate_system Module111 = origin=(0mm, 10*Length, 0mm) x=(1mm, 0mm, 0mm) y=(0mm, 1mm, 0mm)
  coordinate_system Module112 = origin=(0mm, 11*Length, 0mm) x=(1mm, 0mm, 0mm) y=(0mm, 1mm, 0mm)
  coordinate_system Module113 = origin=(0mm, 12*Length, 0mm) x=(1mm, 0mm, 0mm) y=(0mm, 1mm, 0mm)
  coordinate_system Module114 = origin=(0mm, 13*Length, 0mm) x=(1mm, 0mm, 0mm) y=(0mm, 1mm, 0mm)
  coordinate_system Module115 = origin=(0mm, 14*Length, 0mm) x=(1mm, 0mm, 0mm) y=(0mm, 1mm, 0mm)
  coordinate_system Module116 = origin=(0mm, 15*Length, 0mm) x=(1mm, 0mm, 0mm) y=(0mm, 1mm, 0mm)
  coordinate_system Module117 = origin=(0mm, 16*Length, 0mm) x=(1mm, 0mm, 0mm) y=(0mm, 1mm, 0mm)
  coordinate_system Module118 = origin=(0mm, 17*Length, 0mm) x=(1mm, 0mm, 0mm) y=(0mm, 1mm, 0mm)
  coordinate_system Module119 = origin=(0mm, 18*Length, 0mm) x=(1mm, 0mm, 0mm) y=(0mm, 1mm, 0mm)
  coordinate_system Module120 = origin=(0mm, 19*Length, 0mm) x=(1mm, 0mm, 0mm) y=(0mm, 1mm, 0mm)
  coordinate_system Module121 = origin=(0mm, 20*Length, 0mm) x=(1mm, 0mm, 0mm) y=(0mm, 1mm, 0mm)
  coordinate_system Module122 = origin=(0mm, 21*Length, 0mm) x=(1mm, 0mm, 0mm) y=(0mm, 1mm, 0mm)
  coordinate_system Module123 = origin=(0mm, 22*Length, 0mm) x=(1mm, 0mm, 0mm) y=(0mm, 1mm, 0mm)
  coordinate_system Module124 = origin=(0mm, 23*Length, 0mm) x=(1mm, 0mm, 0mm) y=(0mm, 1mm, 0mm)
  coordinate_system Module125 = origin=(0mm, 24*Length, 0mm) x=(1mm, 0mm, 0mm) y=(0mm, 1mm, 0mm)
  coordinate_system Module126 = origin=(0mm, 25*Length, 0mm) x=(1mm, 0mm, 0mm) y=(0mm, 1mm, 0mm)
  coordinate_system Module127 = origin=(0mm, 26*Length, 0mm) x=(1mm, 0mm, 0mm) y=(0mm, 1mm, 0mm)
  coordinate_system Module128 = origin=(0mm, 27*Length, 0mm) x=(1mm, 0mm, 0mm) y=(0mm, 1mm, 0mm)
  coordinate_system Module129 = origin=(0mm, 28*Length, 0mm) x=(1mm, 0mm, 0mm) y=(0mm, 1mm, 0mm)
  coordinate_system Module130 = origin=(0mm, 29*Length, 0mm) x=(1mm, 0mm, 0mm) y=(0mm, 1mm, 0mm)
  coordinate_system Module131 = origin=(0mm, 30*Length, 0mm) x=(1mm, 0mm, 0mm) y=(0mm, 1mm, 0mm)
  coordinate_system Module132 = origin=(0mm, 31*Length, 0mm) x=(1mm, 0mm, 0mm) y=(0mm, 1mm, 0mm)
  HFSSDesign1_2 = component(HFSSDesign1, 3D_Component_File_Path=C:/Users/vemana/Desktop/alphabeta_HELIOS_Footprint.a3dcomp, beta=beta, alpha=alpha12, dz=Width, dy=Length)
  Reflector_Element2 [copper] = part_of(HFSSDesign1_2) in Module12
  HFSSDesign1_3 = component(HFSSDesign1, 3D_Component_File_Path=C:/Users/vemana/Desktop/alphabeta_HELIOS_Footprint.a3dcomp, beta=beta, alpha=alpha13, dz=Width, dy=Length)
  Reflector_Element3 [copper] = part_of(HFSSDesign1_3) in Module13
  HFSSDesign1_4 = component(HFSSDesign1, 3D_Component_File_Path=C:/Users/vemana/Desktop/alphabeta_HELIOS_Footprint.a3dcomp, beta=beta, alpha=alpha14, dz=Width, dy=Length)
  Reflector_Element4 [copper] = part_of(HFSSDesign1_4) in Module14
  HFSSDesign1_5 = component(HFSSDesign1, 3D_Component_File_Path=C:/Users/vemana/Desktop/alphabeta_HELIOS_Footprint.a3dcomp, beta=beta, alpha=alpha15, dz=Width, dy=Length)
  Reflector_Element5 [copper] = part_of(HFSSDesign1_5) in Module15
  HFSSDesign1_6 = component(HFSSDesign1, 3D_Component_File_Path=C:/Users/vemana/Desktop/alphabeta_HELIOS_Footprint.a3dcomp, beta=beta, alpha=alpha16, dz=Width, dy=Length)
  Reflector_Element6 [copper] = part_of(HFSSDesign1_6) in Module16
  HFSSDesign1_7 = component(HFSSDesign1, 3D_Component_File_Path=C:/Users/vemana/Desktop/alphabeta_HELIOS_Footprint.a3dcomp, beta=beta, alpha=alpha17, dz=Width, dy=Length)
  Reflector_Element7 [copper] = part_of(HFSSDesign1_7) in Module17
  HFSSDesign1_8 = component(HFSSDesign1, 3D_Component_File_Path=C:/Users/vemana/Desktop/alphabeta_HELIOS_Footprint.a3dcomp, beta=beta, alpha=alpha18, dz=Width, dy=Length)
  Reflector_Element8 [copper] = part_of(HFSSDesign1_8) in Module18
  HFSSDesign1_9 = component(HFSSDesign1, 3D_Component_File_Path=C:/Users/vemana/Desktop/alphabeta_HELIOS_Footprint.a3dcomp, beta=beta, alpha=alpha19, dz=Width, dy=Length)
  Reflector_Element9 [copper] = part_of(HFSSDesign1_9) in Module19
  HFSSDesign1_10 = component(HFSSDesign1, 3D_Component_File_Path=C:/Users/vemana/Desktop/alphabeta_HELIOS_Footprint.a3dcomp, beta=beta, alpha=alpha110, dz=Width, dy=Length)
  Reflector_Element10 [copper] = part_of(HFSSDesign1_10) in Module110
  HFSSDesign1_11 = component(HFSSDesign1, 3D_Component_File_Path=C:/Users/vemana/Desktop/alphabeta_HELIOS_Footprint.a3dcomp, beta=beta, alpha=alpha111, dz=Width, dy=Length)
  Reflector_Element11 [copper] = part_of(HFSSDesign1_11) in Module111
  HFSSDesign1_12 = component(HFSSDesign1, 3D_Component_File_Path=C:/Users/vemana/Desktop/alphabeta_HELIOS_Footprint.a3dcomp, beta=beta, alpha=alpha112, dz=Width, dy=Length)
  Reflector_Element12 [copper] = part_of(HFSSDesign1_12) in Module112
  HFSSDesign1_13 = component(HFSSDesign1, 3D_Component_File_Path=C:/Users/vemana/Desktop/alphabeta_HELIOS_Footprint.a3dcomp, beta=beta, alpha=alpha113, dz=Width, dy=Length)
  Reflector_Element13 [copper] = part_of(HFSSDesign1_13) in Module113
  HFSSDesign1_14 = component(HFSSDesign1, 3D_Component_File_Path=C:/Users/vemana/Desktop/alphabeta_HELIOS_Footprint.a3dcomp, beta=beta, alpha=alpha114, dz=Width, dy=Length)
  Reflector_Element14 [copper] = part_of(HFSSDesign1_14) in Module114
  HFSSDesign1_15 = component(HFSSDesign1, 3D_Component_File_Path=C:/Users/vemana/Desktop/alphabeta_HELIOS_Footprint.a3dcomp, beta=beta, alpha=alpha115, dz=Width, dy=Length)
  Reflector_Element15 [copper] = part_of(HFSSDesign1_15) in Module115
  HFSSDesign1_16 = component(HFSSDesign1, 3D_Component_File_Path=C:/Users/vemana/Desktop/alphabeta_HELIOS_Footprint.a3dcomp, beta=beta, alpha=alpha116, dz=Width, dy=Length)
  Reflector_Element16 [copper] = part_of(HFSSDesign1_16) in Module116
  HFSSDesign1_17 = component(HFSSDesign1, 3D_Component_File_Path=C:/Users/vemana/Desktop/alphabeta_HELIOS_Footprint.a3dcomp, beta=beta, alpha=alpha117, dz=Width, dy=Length)
  Reflector_Element17 [copper] = part_of(HFSSDesign1_17) in Module117
  HFSSDesign1_18 = component(HFSSDesign1, 3D_Component_File_Path=C:/Users/vemana/Desktop/alphabeta_HELIOS_Footprint.a3dcomp, beta=beta, alpha=alpha118, dz=Width, dy=Length)
  Reflector_Element18 [copper] = part_of(HFSSDesign1_18) in Module118
  HFSSDesign1_19 = component(HFSSDesign1, 3D_Component_File_Path=C:/Users/vemana/Desktop/alphabeta_HELIOS_Footprint.a3dcomp, beta=beta, alpha=alpha119, dz=Width, dy=Length)
  Reflector_Element19 [copper] = part_of(HFSSDesign1_19) in Module119
  HFSSDesign1_20 = component(HFSSDesign1, 3D_Component_File_Path=C:/Users/vemana/Desktop/alphabeta_HELIOS_Footprint.a3dcomp, beta=beta, alpha=alpha120, dz=Width, dy=Length)
  Reflector_Element20 [copper] = part_of(HFSSDesign1_20) in Module120
  HFSSDesign1_21 = component(HFSSDesign1, 3D_Component_File_Path=C:/Users/vemana/Desktop/alphabeta_HELIOS_Footprint.a3dcomp, beta=beta, alpha=alpha121, dz=Width, dy=Length)
  Reflector_Element21 [copper] = part_of(HFSSDesign1_21) in Module121
  HFSSDesign1_22 = component(HFSSDesign1, 3D_Component_File_Path=C:/Users/vemana/Desktop/alphabeta_HELIOS_Footprint.a3dcomp, beta=beta, alpha=alpha122, dz=Width, dy=Length)
  Reflector_Element22 [copper] = part_of(HFSSDesign1_22) in Module122
  HFSSDesign1_23 = component(HFSSDesign1, 3D_Component_File_Path=C:/Users/vemana/Desktop/alphabeta_HELIOS_Footprint.a3dcomp, beta=beta, alpha=alpha123, dz=Width, dy=Length)
  Reflector_Element23 [copper] = part_of(HFSSDesign1_23) in Module123
  HFSSDesign1_24 = component(HFSSDesign1, 3D_Component_File_Path=C:/Users/vemana/Desktop/alphabeta_HELIOS_Footprint.a3dcomp, beta=beta, alpha=alpha124, dz=Width, dy=Length)
  Reflector_Element24 [copper] = part_of(HFSSDesign1_24) in Module124
  HFSSDesign1_25 = component(HFSSDesign1, 3D_Component_File_Path=C:/Users/vemana/Desktop/alphabeta_HELIOS_Footprint.a3dcomp, beta=beta, alpha=alpha125, dz=Width, dy=Length)
  Reflector_Element25 [copper] = part_of(HFSSDesign1_25) in Module125
  HFSSDesign1_26 = component(HFSSDesign1, 3D_Component_File_Path=C:/Users/vemana/Desktop/alphabeta_HELIOS_Footprint.a3dcomp, beta=beta, alpha=alpha126, dz=Width, dy=Length)
  Reflector_Element26 [copper] = part_of(HFSSDesign1_26) in Module126
  HFSSDesign1_27 = component(HFSSDesign1, 3D_Component_File_Path=C:/Users/vemana/Desktop/alphabeta_HELIOS_Footprint.a3dcomp, beta=beta, alpha=alpha127, dz=Width, dy=Length)
  Reflector_Element27 [copper] = part_of(HFSSDesign1_27) in Module127
  HFSSDesign1_28 = component(HFSSDesign1, 3D_Component_File_Path=C:/Users/vemana/Desktop/alphabeta_HELIOS_Footprint.a3dcomp, beta=beta, alpha=alpha128, dz=Width, dy=Length)
  Reflector_Element28 [copper] = part_of(HFSSDesign1_28) in Module128
  HFSSDesign1_29 = component(HFSSDesign1, 3D_Component_File_Path=C:/Users/vemana/Desktop/alphabeta_HELIOS_Footprint.a3dcomp, beta=beta, alpha=alpha129, dz=Width, dy=Length)
  Reflector_Element29 [copper] = part_of(HFSSDesign1_29) in Module129
  HFSSDesign1_30 = component(HFSSDesign1, 3D_Component_File_Path=C:/Users/vemana/Desktop/alphabeta_HELIOS_Footprint.a3dcomp, beta=beta, alpha=alpha130, dz=Width, dy=Length)
  Reflector_Element30 [copper] = part_of(HFSSDesign1_30) in Module130
  HFSSDesign1_31 = component(HFSSDesign1, 3D_Component_File_Path=C:/Users/vemana/Desktop/alphabeta_HELIOS_Footprint.a3dcomp, beta=beta, alpha=alpha131, dz=Width, dy=Length)
  Reflector_Element31 [copper] = part_of(HFSSDesign1_31) in Module131
  HFSSDesign1_32 = component(HFSSDesign1, 3D_Component_File_Path=C:/Users/vemana/Desktop/alphabeta_HELIOS_Footprint.a3dcomp, beta=beta, alpha=alpha132, dz=Width, dy=Length)
  Reflector_Element32 [copper] = part_of(HFSSDesign1_32) in Module132
boundaries and excitations:
  HFSSDesign1_1_SBRRegion1: Hybrid Region Objects=Reflector_Element Type=SBR+
  HFSSDesign1_1_FiniteCond1: Finite Conductivity Objects=Reflector_Element UseMaterial Material=HFSSDesign1_1:copper IsInternal
  HFSSDesign1_2_SBRRegion1: Hybrid Region Objects=Reflector_Element2 Type=SBR+
  HFSSDesign1_2_FiniteCond1: Finite Conductivity Objects=Reflector_Element2 UseMaterial Material=HFSSDesign1_2:copper IsInternal
  HFSSDesign1_3_SBRRegion1: Hybrid Region Objects=Reflector_Element3 Type=SBR+
  HFSSDesign1_3_FiniteCond1: Finite Conductivity Objects=Reflector_Element3 UseMaterial Material=HFSSDesign1_3:copper IsInternal
  HFSSDesign1_4_SBRRegion1: Hybrid Region Objects=Reflector_Element4 Type=SBR+
  HFSSDesign1_4_FiniteCond1: Finite Conductivity Objects=Reflector_Element4 UseMaterial Material=HFSSDesign1_4:copper IsInternal
  HFSSDesign1_5_SBRRegion1: Hybrid Region Objects=Reflector_Element5 Type=SBR+
  HFSSDesign1_5_FiniteCond1: Finite Conductivity Objects=Reflector_Element5 UseMaterial Material=HFSSDesign1_5:copper IsInternal
  HFSSDesign1_6_SBRRegion1: Hybrid Region Objects=Reflector_Element6 Type=SBR+
  HFSSDesign1_6_FiniteCond1: Finite Conductivity Objects=Reflector_Element6 UseMaterial Material=HFSSDesign1_6:copper IsInternal
  HFSSDesign1_7_SBRRegion1: Hybrid Region Objects=Reflector_Element7 Type=SBR+
  HFSSDesign1_7_FiniteCond1: Finite Conductivity Objects=Reflector_Element7 UseMaterial Material=HFSSDesign1_7:copper IsInternal
  HFSSDesign1_8_SBRRegion1: Hybrid Region Objects=Reflector_Element8 Type=SBR+
  HFSSDesign1_8_FiniteCond1: Finite Conductivity Objects=Reflector_Element8 UseMaterial Material=HFSSDesign1_8:copper IsInternal
  HFSSDesign1_9_SBRRegion1: Hybrid Region Objects=Reflector_Element9 Type=SBR+
  HFSSDesign1_9_FiniteCond1: Finite Conductivity Objects=Reflector_Element9 UseMaterial Material=HFSSDesign1_9:copper IsInternal
  HFSSDesign1_10_SBRRegion1: Hybrid Region Objects=Reflector_Element10 Type=SBR+
  HFSSDesign1_10_FiniteCond1: Finite Conductivity Objects=Reflector_Element10 UseMaterial Material=HFSSDesign1_10:copper IsInternal
  HFSSDesign1_11_SBRRegion1: Hybrid Region Objects=Reflector_Element11 Type=SBR+
  HFSSDesign1_11_FiniteCond1: Finite Conductivity Objects=Reflector_Element11 UseMaterial Material=HFSSDesign1_11:copper IsInternal
  HFSSDesign1_12_SBRRegion1: Hybrid Region Objects=Reflector_Element12 Type=SBR+
  HFSSDesign1_12_FiniteCond1: Finite Conductivity Objects=Reflector_Element12 UseMaterial Material=HFSSDesign1_12:copper IsInternal
  HFSSDesign1_13_SBRRegion1: Hybrid Region Objects=Reflector_Element13 Type=SBR+
  HFSSDesign1_13_FiniteCond1: Finite Conductivity Objects=Reflector_Element13 UseMaterial Material=HFSSDesign1_13:copper IsInternal
  HFSSDesign1_14_SBRRegion1: Hybrid Region Objects=Reflector_Element14 Type=SBR+
  HFSSDesign1_14_FiniteCond1: Finite Conductivity Objects=Reflector_Element14 UseMaterial Material=HFSSDesign1_14:copper IsInternal
  HFSSDesign1_15_SBRRegion1: Hybrid Region Objects=Reflector_Element15 Type=SBR+
  HFSSDesign1_15_FiniteCond1: Finite Conductivity Objects=Reflector_Element15 UseMaterial Material=HFSSDesign1_15:copper IsInternal
  HFSSDesign1_16_SBRRegion1: Hybrid Region Objects=Reflector_Element16 Type=SBR+
  HFSSDesign1_16_FiniteCond1: Finite Conductivity Objects=Reflector_Element16 UseMaterial Material=HFSSDesign1_16:copper IsInternal
  HFSSDesign1_17_SBRRegion1: Hybrid Region Objects=Reflector_Element17 Type=SBR+
  HFSSDesign1_17_FiniteCond1: Finite Conductivity Objects=Reflector_Element17 UseMaterial Material=HFSSDesign1_17:copper IsInternal
  HFSSDesign1_18_SBRRegion1: Hybrid Region Objects=Reflector_Element18 Type=SBR+
  HFSSDesign1_18_FiniteCond1: Finite Conductivity Objects=Reflector_Element18 UseMaterial Material=HFSSDesign1_18:copper IsInternal
  HFSSDesign1_19_SBRRegion1: Hybrid Region Objects=Reflector_Element19 Type=SBR+
  HFSSDesign1_19_FiniteCond1: Finite Conductivity Objects=Reflector_Element19 UseMaterial Material=HFSSDesign1_19:copper IsInternal
  HFSSDesign1_20_SBRRegion1: Hybrid Region Objects=Reflector_Element20 Type=SBR+
  HFSSDesign1_20_FiniteCond1: Finite Conductivity Objects=Reflector_Element20 UseMaterial Material=HFSSDesign1_20:copper IsInternal
  HFSSDesign1_21_SBRRegion1: Hybrid Region Objects=Reflector_Element21 Type=SBR+
  HFSSDesign1_21_FiniteCond1: Finite Conductivity Objects=Reflector_Element21 UseMaterial Material=HFSSDesign1_21:copper IsInternal
  HFSSDesign1_22_SBRRegion1: Hybrid Region Objects=Reflector_Element22 Type=SBR+
  HFSSDesign1_22_FiniteCond1: Finite Conductivity Objects=Reflector_Element22 UseMaterial Material=HFSSDesign1_22:copper IsInternal
  HFSSDesign1_23_SBRRegion1: Hybrid Region Objects=Reflector_Element23 Type=SBR+
  HFSSDesign1_23_FiniteCond1: Finite Conductivity Objects=Reflector_Element23 UseMaterial Material=HFSSDesign1_23:copper IsInternal
  HFSSDesign1_24_SBRRegion1: Hybrid Region Objects=Reflector_Element24 Type=SBR+
  HFSSDesign1_24_FiniteCond1: Finite Conductivity Objects=Reflector_Element24 UseMaterial Material=HFSSDesign1_24:copper IsInternal
  HFSSDesign1_25_SBRRegion1: Hybrid Region Objects=Reflector_Element25 Type=SBR+
  HFSSDesign1_25_FiniteCond1: Finite Conductivity Objects=Reflector_Element25 UseMaterial Material=HFSSDesign1_25:copper IsInternal
  HFSSDesign1_26_SBRRegion1: Hybrid Region Objects=Reflector_Element26 Type=SBR+
  HFSSDesign1_26_FiniteCond1: Finite Conductivity Objects=Reflector_Element26 UseMaterial Material=HFSSDesign1_26:copper IsInternal
  HFSSDesign1_27_SBRRegion1: Hybrid Region Objects=Reflector_Element27 Type=SBR+
  HFSSDesign1_27_FiniteCond1: Finite Conductivity Objects=Reflector_Element27 UseMaterial Material=HFSSDesign1_27:copper IsInternal
  HFSSDesign1_28_SBRRegion1: Hybrid Region Objects=Reflector_Element28 Type=SBR+
  HFSSDesign1_28_FiniteCond1: Finite Conductivity Objects=Reflector_Element28 UseMaterial Material=HFSSDesign1_28:copper IsInternal
  HFSSDesign1_29_SBRRegion1: Hybrid Region Objects=Reflector_Element29 Type=SBR+
  HFSSDesign1_29_FiniteCond1: Finite Conductivity Objects=Reflector_Element29 UseMaterial Material=HFSSDesign1_29:copper IsInternal
  HFSSDesign1_30_SBRRegion1: Hybrid Region Objects=Reflector_Element30 Type=SBR+
  HFSSDesign1_30_FiniteCond1: Finite Conductivity Objects=Reflector_Element30 UseMaterial Material=HFSSDesign1_30:copper IsInternal
  HFSSDesign1_31_SBRRegion1: Hybrid Region Objects=Reflector_Element31 Type=SBR+
  HFSSDesign1_31_FiniteCond1: Finite Conductivity Objects=Reflector_Element31 UseMaterial Material=HFSSDesign1_31:copper IsInternal
  HFSSDesign1_32_SBRRegion1: Hybrid Region Objects=Reflector_Element32 Type=SBR+
  HFSSDesign1_32_FiniteCond1: Finite Conductivity Objects=Reflector_Element32 UseMaterial Material=HFSSDesign1_32:copper IsInternal
  IncPWave1: Plane Incident Wave PhiStart="(180+az_angle*180/pi) deg" PhiStop="(180+az_angle*180/pi) deg" PhiPoints=1 ThetaStart="-el_angle*180/pi deg" ThetaStop="-el_angle*180/pi deg" ThetaPoints=1 EoPhi=1 EoTheta=0 OriginX=spacing_x OriginY=spacing_y OriginZ=spacing_z IsPropagating
setups:
  Setup1: HfssDriven RayDensityPerWavelength=4 MaxNumberOfBounces=5 RadiationSetup=1 PTDUTDSimulationSettings="PTD Correction + UTD Rays" PTDEdgeDensity=20 ComputeFarFields
    sweep Sweep: point 28GHz;
source amplitudes:
  IncPWave1:1: 1 0deg
radiation setups:
  FarField_Setup: Infinite Sphere Theta=0deg..180deg step 1deg Phi=-90deg..90deg step 1deg
reports:
  FarField_Report: dB(RCSTotal) vs Phi, Theta on Setup1 : Sweep, FarField_Setup [Freq=28GHz IWavePhi=10313.2deg IWaveTheta=-5156.62deg]
