# Ansys Electronics Desktop project, version 2021.2
materials:
  vacuum: permittivity=1
  pec: conductivity=1e+30

design HFSSDesign1 (HFSS, SBR+, model units mm)
variables:
  alpha11 = beta11
  beta11 = 10deg
  Len_11 = Length
  Wid_11 = Width
  spacing_magnitude = 1meter
  el_angle = 100deg
  az_angle = 10deg
  spacing_x = spacing_magnitude*sin(el_angle*pi/180 deg)*cos(az_angle*pi/180 deg)
  spacing_y = spacing_magnitude*sin(el_angle*pi/180 deg)*sin(-1*az_angle*pi/180 deg)
  spacing_z = spacing_magnitude*cos(el_angle*pi/180 deg)
  Length = 10cm
  Width = 10cm
  alpha12 = alpha11
  beta12 = beta11
  Len_12 = Len_11
  Wid_12 = Wid_11
  alpha21 = alpha11
  beta21 = beta11
  Len_21 = Len_11
  Wid_21 = Wid_11
  alpha22 = alpha12
  beta22 = beta12
  Len_22 = Len_12
  Wid_22 = Wid_12
  Len_13 = Len_12
  alpha13 = alpha12
  beta13 = beta12
  Wid_13 = Wid_12
  alpha23 = alpha13
  beta23 = beta13
  Len_23 = Len_13
  Wid_23 = Wid_13
  alpha31 = alpha21
  beta31 = beta21
  Len_31 = Len_21
  Wid_31 = Wid_21
  alpha32 = alpha22
  beta32 = beta22
  Len_32 = Len_22
  Wid_32 = WId_22
  alpha33 = alpha23
  beta33 = beta23
  Len_33 = Len_23
  Wid_33 = Wid_23
  beta14 = beta13
  Len_14 = Len_13
  Wid_14 = Wid_13
  alpha14 = alpha13
  alpha24 = alpha14
  beta24 = beta14
  Len_24 = Len_14
  Wid_24 = Wid_14
  alpha34 = alpha24
  beta34 = beta24
  Len_34 = Len_24
  Wid_34 = Wid_24
  alpha41 = alpha31
  beta41 = beta31
  Len_41 = Len_31
  Wid_41 = Wid_31
  alpha42 = alpha32
  beta42 = beta32
  Len_42 = Len_32
  Wid_42 = Wid_32
  alpha43 = alpha33
  beta43 = beta33
  Len_43 = Len_33
  Wid_43 = Wid_33
  alpha44 = alpha34
  beta44 = beta34
  Len_44 = Len_34
  Wid_44 = Wid_34
  Len_15 = Len_14
  beta15 = beta14
  alpha15 = alpha14
  Wid_15 = Wid_14
  alpha25 = alpha15
  beta25 = beta15
  Len_25 = Len_15
  Wid_25 = Wid_15
  alpha35 = alpha25
  beta35 = beta25
  Len_35 = Len_25
  Wid_35 = Wid_25
  alpha45 = alpha35
  beta45 = beta35
  Len_45 = Len_35
  Wid_45 = Wid_35
  alpha55 = alpha45
  beta55 = beta45
  Len_55 = Len_45
  Wid_55 = Wid_45
  alpha54 = alpha44
  beta54 = beta44
  Len_54 = Len_44
  Wid_54 = Wid_44
  alpha53 = alpha43
  beta53 = beta43
  Len_53 = Len_43
  Wid_53 = Wid_43
  alpha52 = alpha42
  beta52 = beta42
  Len_52 = Len_42
  Wid_52 = Wid_42
  alpha51 = alpha41
  beta51 = beta41
  Len_51 = Len_41
  Wid_51 = Wid_41
  Len_16 = Len_15
  beta16 = beta15
  Wid_16 = Wid_15
  alpha16 = alpha15
  alpha26 = alpha16
  beta26 = beta16
  Len_26 = Len_16
  Wid_26 = Wid_16
  alpha36 = alpha26
  beta36 = beta26
  Len_36 = Len_26
  Wid_36 = WId_26
  alpha46 = alpha36
  beta46 = beta36
  Len_46 = Len_36
  Wid_46 = Wid_36
  alpha56 = alpha46
  beta56 = beta46
  Len_56 = Len_46
  Wid_56 = Wid_46
  alpha66 = alpha56
  beta66 = beta56
  Len_66 = Len_56
  Wid_66 = Wid_56
  alpha65 = alpha55
  beta65 = beta55
  Len_65 = Len_55
  Wid_65 = Wid_55
  alpha64 = alpha54
  beta64 = beta54
  Len_64 = Len_54
  Wid_64 = Wid_54
  alpha63 = alpha53
  beta63 = beta53
  Len_63 = Len_53
  Wid_63 = Wid_53
  alpha62 = alpha52
  beta62 = beta52
  Len_62 = Len_52
  Wid_62 = Wid_52
  alpha61 = alpha51
  beta61 = beta51
  Len_61 = Len_51
  Wid_61 = Wid_51
  Wid_17 = Wid_16
  beta17 = beta16
  alpha17 = alpha16
  Len_17 = Len_16
  alpha27 = alpha17
  beta27 = beta17
  Len_27 = Len_17
  Wid_27 = Wid_17
  alpha37 = alpha27
  beta37 = beta27
  Len_37 = Len_27
  Wid_37 = Wid_27
  alpha47 = alpha37
  beta47 = beta37
  Len_47 = Len_37
  Wid_47 = Wid_37
  alpha57 = alpha47
  beta57 = beta47
  Len_57 = Len_47
  Wid_57 = Wid_47
  alpha67 = alpha57
  beta67 = beta57
  Len_67 = Len_57
  Wid_67 = Wid_57
  alpha77 = alpha67
  beta77 = beta67
  Len_77 = Len_67
  Wid_77 = Wid_67
  alpha76 = alpha66
  beta76 = beta66
  Len_76 = Len_66
  Wid_76 = Wid_66
  alpha75 = alpha65
  beta75 = beta65
  Len_75 = Len_65
  Wid_75 = Wid_65
  alpha74 = alpha64
  beta74 = beta64
  Len_74 = Len_64
  Wid_74 = Wid_64
  alpha73 = alpha63
  beta73 = beta63
  Len_73 = Len_63
  Wid_73 = Wid_63
  alpha72 = alpha62
  beta72 = beta62
  Len_72 = Len_62
  Wid_72 = Wid_62
  alpha71 = alpha61
  beta71 = beta61
  Len_71 = Len_61
  Wid_71 = Wid_61
geometry:
  coordinate_system module11 = origin=(0mm, 0mm, 0mm) x=(1mm, 0mm, 0mm) y=(0mm, 1mm, 0mm)
  coordinate_system module12 = origin=(0mm, Length, 0mm) x=(1mm, 0mm, 0mm) y=(0mm, 1mm, 0mm)
  coordinate_system module21 = origin=(0mm, 0mm, Width) x=(1mm, 0mm, 0mm) y=(0mm, 1mm, 0mm)
  coordinate_system module22 = origin=(0mm, Length, Width) x=(1mm, 0mm, 0mm) y=(0mm, 1mm, 0mm)
  coordinate_system module13 = origin=(0mm, 2*Length, 0mm) x=(1mm, 0mm, 0mm) y=(0mm, 1mm, 0mm)
  coordinate_system module23 = origin=(0mm, 2*Length, Width) x=(1mm, 0mm, 0mm) y=(0mm, 1mm, 0mm)
  coordinate_system module31 = origin=(0mm, 0mm, 2*Width) x=(1mm, 0mm, 0mm) y=(0mm, 1mm, 0mm)
  coordinate_system module32 = origin=(0mm, Length, 2*Width) x=(1mm, 0mm, 0mm) y=(0mm, 1mm, 0mm)
  coordinate_system module33 = origin=(0mm, 2*Length, 2*Width) x=(1mm, 0mm, 0mm) y=(0mm, 1mm, 0mm)
  coordinate_system module14 = origin=(0mm, 3*Length, 0mm) x=(1mm, 0mm, 0mm) y=(0mm, 1mm, 0mm)
  coordinate_system module24 = origin=(0mm, 3*Length, Width) x=(1mm, 0mm, 0mm) y=(0mm, 1mm, 0mm)
  coordinate_system module34 = origin=(0mm, 3*Length, 2*Width) x=(1mm, 0mm, 0mm) y=(0mm, 1mm, 0mm)
  coordinate_system module41 = origin=(0mm, 0mm, 3*Width) x=(1mm, 0mm, 0mm) y=(0mm, 1mm, 0mm)
  coordinate_system module42 = origin=(0mm, Length, 3*Width) x=(1mm, 0mm, 0mm) y=(0mm, 1mm, 0mm)
  coordinate_system module43 = origin=(0mm, 2*Length, 3*Width) x=(1mm, 0mm, 0mm) y=(0mm, 1mm, 0mm)
  coordinate_system module44 = origin=(0mm, 3*Length, 3*Width) x=(1mm, 0mm, 0mm) y=(0mm, 1mm, 0mm)
  coordinate_system module15 = origin=(0mm, 4*Length, 0mm) x=(1mm, 0mm, 0mm) y=(0mm, 1mm, 0mm)
  coordinate_system module25 = origin=(0mm, 4*Length, Width) x=(1mm, 0mm, 0mm) y=(0mm, 1mm, 0mm)
  coordinate_system module35 = origin=(0mm, 4*Length, 2*Width) x=(1mm, 0mm, 0mm) y=(0mm, 1mm, 0mm)
  coordinate_system module45 = origin=(0mm, 4*Length, 3*Width) x=(1mm, 0mm, 0mm) y=(0mm, 1mm, 0mm)
  coordinate_system module55 = origin=(0mm, 4*Length, 4*Width) x=(1mm, 0mm, 0mm) y=(0mm, 1mm, 0mm)
  coordinate_system module54 = origin=(0mm, 3*Length, 4*Width) x=(1mm, 0mm, 0mm) y=(0mm, 1mm, 0mm)
  coordinate_system module53 = origin=(0mm, 2*Length, 4*Width) x=(1mm, 0mm, 0mm) y=(0mm, 1mm, 0mm)
  coordinate_system module52 = origin=(0mm, 1*Length, 4*Width) x=(1mm, 0mm, 0mm) y=(0mm, 1mm, 0mm)
  coordinate_system module51 = origin=(0mm, 0mm, 4*Width) x=(1mm, 0mm, 0mm) y=(0mm, 1mm, 0mm)
  coordinate_system module16 = origin=(0mm, 5*Length, 0mm) x=(1mm, 0mm, 0mm) y=(0mm, 1mm, 0mm)
  coordinate_system module26 = origin=(0mm, 5*Length, Width) x=(1mm, 0mm, 0mm) y=(0mm, 1mm, 0mm)
  coordinate_system module36 = origin=(0mm, 5*Length, 2*Width) x=(1mm, 0mm, 0mm) y=(0mm, 1mm, 0mm)
  coordinate_system module46 = origin=(0mm, 5*Length, 3*Width) x=(1mm, 0mm, 0mm) y=(0mm, 1mm, 0mm)
  coordinate_system module56 = origin=(0mm, 5*Length, 4*Width) x=(1mm, 0mm, 0mm) y=(0mm, 1mm, 0mm)
  coordinate_system module66 = origin=(0mm, 5*Length, 5*Width) x=(1mm, 0mm, 0mm) y=(0mm, 1mm, 0mm)
  coordinate_system module65 = origin=(0mm, 4*Length, 5*Width) x=(1mm, 0mm, 0mm) y=(0mm, 1mm, 0mm)
  coordinate_system module64 = origin=(0mm, 3*Length, 5*Width) x=(1mm, 0mm, 0mm) y=(0mm, 1mm, 0mm)
  coordinate_system module63 = origin=(0mm, 2*Length, 5*Width) x=(1mm, 0mm, 0mm) y=(0mm, 1mm, 0mm)
  coordinate_system module62 = origin=(0mm, 1*Length, 5*Width) x=(1mm, 0mm, 0mm) y=(0mm, 1mm, 0mm)
  coordinate_system module61 = origin=(0mm, 0*Width, 5*Width) x=(1mm, 0mm, 0mm) y=(0mm, 1mm, 0mm)
  coordinate_system module17 = origin=(0mm, 6*Length, 0mm) x=(1mm, 0mm, 0mm) y=(0mm, 1mm, 0mm)
  coordinate_system module27 = origin=(0mm, 6 *Length, Width) x=(1mm, 0mm, 0mm) y=(0mm, 1mm, 0mm)
  coordinate_system module37 = origin=(0mm, 6*Length, 2*Width) x=(1mm, 0mm, 0mm) y=(0mm, 1mm, 0mm)
  coordinate_system module47 = origin=(0mm, 6*Length, 3*Width) x=(1mm, 0mm, 0mm) y=(0mm, 1mm, 0mm)
  coordinate_system module57 = origin=(0mm, 6*Length, 4*Width) x=(1mm, 0mm, 0mm) y=(0mm, 1mm, 0mm)
  coordinate_system module67 = origin=(0mm, 6*Length, 5*Width) x=(1mm, 0mm, 0mm) y=(0mm, 1mm, 0mm)
  coordinate_system module77 = origin=(0mm, 6*Length, 6*Width) x=(1mm, 0mm, 0mm) y=(0mm, 1mm, 0mm)
  coordinate_system module76 = origin=(0mm, 5*Length, 6*Width) x=(1mm, 0mm, 0mm) y=(0mm, 1mm, 0mm)
  coordinate_system module75 = origin=(0mm, 4*Length, 6*Width) x=(1mm, 0mm, 0mm) y=(0mm, 1mm, 0mm)
  coordinate_system module74 = origin=(0mm, 3*Length, 6*Width) x=(1mm, 0mm, 0mm) y=(0mm, 1mm, 0mm)
  coordinate_system module73 = origin=(0mm, 2*Length, 6*Width) x=(1mm, 0mm, 0mm) y=(0mm, 1mm, 0mm)
  coordinate_system module72 = origin=(0mm, 1*Length, 6*Width) x=(1mm, 0mm, 0mm) y=(0mm, 1mm, 0mm)
  coordinate_system module71 = origin=(0mm, 0*Length, 6*Width) x=(1mm, 0mm, 0mm) y=(0mm, 1mm, 0mm)
  HFSSDesign1_1 = component(HFSSDesign1, 3D_Component_File_Path=C:/Users/vemana/Desktop/Modified_HELIOS_Footprint.a3dcomp, beta=beta11, dy=Len_11, alpha=alpha11, dz=Wid_11)
  Reflector_Element [copper] = part_of(HFSSDesign1_1) in module11
  HFSSDesign1_2 = component(HFSSDesign1, 3D_Component_File_Path=C:/Users/vemana/Desktop/Modified_HELIOS_Footprint.a3dcomp, beta=beta12, dy=Len_12, alpha=alpha12, dz=Wid_12)
  Reflector_Element2 [copper] = part_of(HFSSDesign1_2) in module12
  HFSSDesign1_3 = component(HFSSDesign1, 3D_Component_File_Path=C:/Users/vemana/Desktop/Modified_HELIOS_Footprint.a3dcomp, beta=beta13, dy=Len_13, alpha=alpha13, dz=Wid_13)
  Reflector_Element3 [copper] = part_of(HFSSDesign1_3) in module13
  HFSSDesign1_4 = component(HFSSDesign1, 3D_Component_File_Path=C:/Users/vemana/Desktop/Modified_HELIOS_Footprint.a3dcomp, beta=beta14, dy=Len_14, alpha=alpha14, dz=Wid_14)
  Reflector_Element4 [copper] = part_of(HFSSDesign1_4) in module14
  HFSSDesign1_5 = component(HFSSDesign1, 3D_Component_File_Path=C:/Users/vemana/Desktop/Modified_HELIOS_Footprint.a3dcomp, beta=beta15, dy=Len_15, alpha=alpha15, dz=Wid_15)
  Reflector_Element5 [copper] = part_of(HFSSDesign1_5) in module15
  HFSSDesign1_6 = component(HFSSDesign1, 3D_Component_File_Path=C:/Users/vemana/Desktop/Modified_HELIOS_Footprint.a3dcomp, beta=beta16, dy=Len_16, alpha=alpha16, dz=Wid_16)
  Reflector_Element6 [copper] = part_of(HFSSDesign1_6) in module16
  HFSSDesign1_7 = component(HFSSDesign1, 3D_Component_File_Path=C:/Users/vemana/Desktop/Modified_HELIOS_Footprint.a3dcomp, beta=beta17, dy=Len_17, alpha=alpha17, dz=Wid_17)
  Reflector_Element7 [copper] = part_of(HFSSDesign1_7) in module17
  HFSSDesign1_8 = component(HFSSDesign1, 3D_Component_File_Path=C:/Users/vemana/Desktop/Modified_HELIOS_Footprint.a3dcomp, beta=beta21, dy=Len_21, alpha=alpha21, dz=Wid_21)
  Reflector_Element8 [copper] = part_of(HFSSDesign1_8) in module21
  HFSSDesign1_9 = component(HFSSDesign1, 3D_Component_File_Path=C:/Users/vemana/Desktop/Modified_HELIOS_Footprint.a3dcomp, beta=beta22, dy=Len_22, alpha=alpha22, dz=Wid_22)
  Reflector_Element9 [copper] = part_of(HFSSDesign1_9) in module22
  HFSSDesign1_10 = component(HFSSDesign1, 3D_Component_File_Path=C:/Users/vemana/Desktop/Modified_HELIOS_Footprint.a3dcomp, beta=beta23, dy=Len_23, alpha=alpha23, dz=Wid_23)
  Reflector_Element10 [copper] = part_of(HFSSDesign1_10) in module23
  HFSSDesign1_11 = component(HFSSDesign1, 3D_Component_File_Path=C:/Users/vemana/Desktop/Modified_HELIOS_Footprint.a3dcomp, beta=beta24, dy=Len_24, alpha=alpha24, dz=Wid_24)
  Reflector_Element11 [copper] = part_of(HFSSDesign1_11) in module24
  HFSSDesign1_12 = component(HFSSDesign1, 3D_Component_File_Path=C:/Users/vemana/Desktop/Modified_HELIOS_Footprint.a3dcomp, beta=beta25, dy=Len_25, alpha=alpha25, dz=Wid_25)
  Reflector_Element12 [copper] = part_of(HFSSDesign1_12) in module25
  HFSSDesign1_13 = component(HFSSDesign1, 3D_Component_File_Path=C:/Users/vemana/Desktop/Modified_HELIOS_Footprint.a3dcomp, beta=beta26, dy=Len_26, alpha=alpha26, dz=Wid_26)
  Reflector_Element13 [copper] = part_of(HFSSDesign1_13) in module26
  HFSSDesign1_14 = component(HFSSDesign1, 3D_Component_File_Path=C:/Users/vemana/Desktop/Modified_HELIOS_Footprint.a3dcomp, beta=beta27, dy=Len_27, alpha=alpha27, dz=Wid_27)
  Reflector_Element14 [copper] = part_of(HFSSDesign1_14) in module27
  HFSSDesign1_15 = component(HFSSDesign1, 3D_Component_File_Path=C:/Users/vemana/Desktop/Modified_HELIOS_Footprint.a3dcomp, beta=beta31, dy=Len_31, alpha=alpha31, dz=Wid_31)
  Reflector_Element15 [copper] = part_of(HFSSDesign1_15) in module31
  HFSSDesign1_16 = component(HFSSDesign1, 3D_Component_File_Path=C:/Users/vemana/Desktop/Modified_HELIOS_Footprint.a3dcomp, beta=beta32, dy=Len_32, alpha=alpha32, dz=Wid_32)
  Reflector_Element16 [copper] = part_of(HFSSDesign1_16) in module32
  HFSSDesign1_17 = component(HFSSDesign1, 3D_Component_File_Path=C:/Users/vemana/Desktop/Modified_HELIOS_Footprint.a3dcomp, beta=beta33, dy=Len_33, alpha=alpha33, dz=Wid_33)
  Reflector_Element17 [copper] = part_of(HFSSDesign1_17) in module33
  HFSSDesign1_18 = component(HFSSDesign1, 3D_Component_File_Path=C:/Users/vemana/Desktop/Modified_HELIOS_Footprint.a3dcomp, beta=beta34, dy=Len_34, alpha=alpha34, dz=Wid_34)
  Reflector_Element18 [copper] = part_of(HFSSDesign1_18) in module34
  HFSSDesign1_19 = component(HFSSDesign1, 3D_Component_File_Path=C:/Users/vemana/Desktop/Modified_HELIOS_Footprint.a3dcomp, beta=beta35, dy=Len_35, alpha=alpha35, dz=Wid_35)
  Reflector_Element19 [copper] = part_of(HFSSDesign1_19) in module35
  HFSSDesign1_20 = component(HFSSDesign1, 3D_Component_File_Path=C:/Users/vemana/Desktop/Modified_HELIOS_Footprint.a3dcomp, beta=beta36, dy=Len_36, alpha=alpha36, dz=Wid_36)
  Reflector_Element20 [copper] = part_of(HFSSDesign1_20) in module36
  HFSSDesign1_21 = component(HFSSDesign1, 3D_Component_File_Path=C:/Users/vemana/Desktop/Modified_HELIOS_Footprint.a3dcomp, beta=beta37, dy=Len_37, alpha=alpha37, dz=Wid_37)
  Reflector_Element21 [copper] = part_of(HFSSDesign1_21) in module37
  HFSSDesign1_22 = component(HFSSDesign1, 3D_Component_File_Path=C:/Users/vemana/Desktop/Modified_HELIOS_Footprint.a3dcomp, beta=beta41, dy=Len_41, alpha=alpha41, dz=Wid_41)
  Reflector_Element22 [copper] = part_of(HFSSDesign1_22) in module41
  HFSSDesign1_23 = component(HFSSDesign1, 3D_Component_File_Path=C:/Users/vemana/Desktop/Modified_HELIOS_Footprint.a3dcomp, beta=beta42, dy=Len_42, alpha=alpha42, dz=Wid_42)
  Reflector_Element23 [copper] = part_of(HFSSDesign1_23) in module42
  HFSSDesign1_24 = component(HFSSDesign1, 3D_Component_File_Path=C:/Users/vemana/Desktop/Modified_HELIOS_Footprint.a3dcomp, beta=beta43, dy=Len_43, alpha=alpha43, dz=Wid_43)
  Reflector_Element24 [copper] = part_of(HFSSDesign1_24) in module43
  HFSSDesign1_25 = component(HFSSDesign1, 3D_Component_File_Path=C:/Users/vemana/Desktop/Modified_HELIOS_Footprint.a3dcomp, beta=beta44, dy=Len_44, alpha=alpha44, dz=Wid_44)
  Reflector_Element25 [copper] = part_of(HFSSDesign1_25) in module44
  HFSSDesign1_26 = component(HFSSDesign1, 3D_Component_File_Path=C:/Users/vemana/Desktop/Modified_HELIOS_Footprint.a3dcomp, beta=beta45, dy=Len_45, alpha=alpha45, dz=Wid_45)
  Reflector_Element26 [copper] = part_of(HFSSDesign1_26) in module45
  HFSSDesign1_27 = component(HFSSDesign1, 3D_Component_File_Path=C:/Users/vemana/Desktop/Modified_HELIOS_Footprint.a3dcomp, beta=beta46, dy=Len_46, alpha=alpha46, dz=Wid_46)
  Reflector_Element27 [copper] = part_of(HFSSDesign1_27) in module46
  HFSSDesign1_28 = component(HFSSDesign1, 3D_Component_File_Path=C:/Users/vemana/Desktop/Modified_HELIOS_Footprint.a3dcomp, beta=beta47, dy=Len_47, alpha=alpha47, dz=Wid_47)
  Reflector_Element28 [copper] = part_of(HFSSDesign1_28) in module47
  HFSSDesign1_29 = component(HFSSDesign1, 3D_Component_File_Path=C:/Users/vemana/Desktop/Modified_HELIOS_Footprint.a3dcomp, beta=beta51, dy=Len_51, alpha=alpha51, dz=Wid_51)
  Reflector_Element29 [copper] = part_of(HFSSDesign1_29) in module51
  HFSSDesign1_30 = component(HFSSDesign1, 3D_Component_File_Path=C:/Users/vemana/Desktop/Modified_HELIOS_Footprint.a3dcomp, beta=beta52, dy=Len_52, alpha=alpha52, dz=Wid_52)
  Reflector_Element30 [copper] = part_of(HFSSDesign1_30) in module52
  HFSSDesign1_31 = component(HFSSDesign1, 3D_Component_File_Path=C:/Users/vemana/Desktop/Modified_HELIOS_Footprint.a3dcomp, beta=beta53, dy=Len_53, alpha=alpha53, dz=Wid_53)
  Reflector_Element31 [copper] = part_of(HFSSDesign1_31) in module53
  HFSSDesign1_32 = component(HFSSDesign1, 3D_Component_File_Path=C:/Users/vemana/Desktop/Modified_HELIOS_Footprint.a3dcomp, beta=beta54, dy=Len_54, alpha=alpha54, dz=Wid_54)
  Reflector_Element32 [copper] = part_of(HFSSDesign1_32) in module54
  HFSSDesign1_33 = component(HFSSDesign1, 3D_Component_File_Path=C:/Users/vemana/Desktop/Modified_HELIOS_Footprint.a3dcomp, beta=beta55, dy=Len_55, alpha=alpha55, dz=Wid_55)
  Reflector_Element33 [copper] = part_of(HFSSDesign1_33) in module55
  HFSSDesign1_34 = component(HFSSDesign1, 3D_Component_File_Path=C:/Users/vemana/Desktop/Modified_HELIOS_Footprint.a3dcomp, beta=beta56, dy=Len_56, alpha=alpha56, dz=Wid_56)
  Reflector_Element34 [copper] = part_of(HFSSDesign1_34) in module56
  HFSSDesign1_35 = component(HFSSDesign1, 3D_Component_File_Path=C:/Users/vemana/Desktop/Modified_HELIOS_Footprint.a3dcomp, beta=beta57, dy=Len_57, alpha=alpha57, dz=Wid_57)
  Reflector_Element35 [copper] = part_of(HFSSDesign1_35) in module57
  HFSSDesign1_36 = component(HFSSDesign1, 3D_Component_File_Path=C:/Users/vemana/Desktop/Modified_HELIOS_Footprint.a3dcomp, beta=beta61, dy=Len_61, alpha=alpha61, dz=Wid_61)
  Reflector_Element36 [copper] = part_of(HFSSDesign1_36) in module61
  HFSSDesign1_37 = component(HFSSDesign1, 3D_Component_File_Path=C:/Users/vemana/Desktop/Modified_HELIOS_Footprint.a3dcomp, beta=beta62, dy=Len_62, alpha=alpha62, dz=Wid_62)
  Reflector_Element37 [copper] = part_of(HFSSDesign1_37) in module62
  HFSSDesign1_38 = component(HFSSDesign1, 3D_Component_File_Path=C:/Users/vemana/Desktop/Modified_HELIOS_Footprint.a3dcomp, beta=beta63, dy=Len_63, alpha=alpha63, dz=Wid_63)
  Reflector_Element38 [copper] = part_of(HFSSDesign1_38) in module63
  HFSSDesign1_39 = component(HFSSDesign1, 3D_Component_File_Path=C:/Users/vemana/Desktop/Modified_HELIOS_Footprint.a3dcomp, beta=beta64, dy=Len_64, alpha=alpha64, dz=Wid_64)
  Reflector_Element39 [copper] = part_of(HFSSDesign1_39) in module64
  HFSSDesign1_40 = component(HFSSDesign1, 3D_Component_File_Path=C:/Users/vemana/Desktop/Modified_HELIOS_Footprint.a3dcomp, beta=beta65, dy=Len_65, alpha=alpha65, dz=Wid_65)
  Reflector_Element40 [copper] = part_of(HFSSDesign1_40) in module65
  HFSSDesign1_41 = component(HFSSDesign1, 3D_Component_File_Path=C:/Users/vemana/Desktop/Modified_HELIOS_Footprint.a3dcomp, beta=beta66, dy=Len_66, alpha=alpha66, dz=Wid_66)
  Reflector_Element41 [copper] = part_of(HFSSDesign1_41) in module66
  HFSSDesign1_42 = component(HFSSDesign1, 3D_Component_File_Path=C:/Users/vemana/Desktop/Modified_HELIOS_Footprint.a3dcomp, beta=beta67, dy=Len_67, alpha=alpha67, dz=Wid_67)
  Reflector_Element42 [copper] = part_of(HFSSDesign1_42) in module67
  HFSSDesign1_43 = component(HFSSDesign1, 3D_Component_File_Path=C:/Users/vemana/Desktop/Modified_HELIOS_Footprint.a3dcomp, beta=beta71, dy=Len_71, alpha=alpha71, dz=Wid_71)
  Reflector_Element43 [copper] = part_of(HFSSDesign1_43) in module71
  HFSSDesign1_44 = component(HFSSDesign1, 3D_Component_File_Path=C:/Users/vemana/Desktop/Modified_HELIOS_Footprint.a3dcomp, beta=beta72, dy=Len_72, alpha=alpha72, dz=Wid_72)
  Reflector_Element44 [copper] = part_of(HFSSDesign1_44) in module72
  HFSSDesign1_45 = component(HFSSDesign1, 3D_Component_File_Path=C:/Users/vemana/Desktop/Modified_HELIOS_Footprint.a3dcomp, beta=beta73, dy=Len_73, alpha=alpha73, dz=Wid_73)
  Reflector_Element45 [copper] = part_of(HFSSDesign1_45) in module73
  HFSSDesign1_46 = component(HFSSDesign1, 3D_Component_File_Path=C:/Users/vemana/Desktop/Modified_HELIOS_Footprint.a3dcomp, beta=beta74, dy=Len_74, alpha=alpha74, dz=Wid_74)
  Reflector_Element46 [copper] = part_of(HFSSDesign1_46) in module74
  HFSSDesign1_47 = component(HFSSDesign1, 3D_Component_File_Path=C:/Users/vemana/Desktop/Modified_HELIOS_Footprint.a3dcomp, beta=beta75, dy=Len_75, alpha=alpha75, dz=Wid_75)
  Reflector_Element47 [copper] = part_of(HFSSDesign1_47) in module75
  HFSSDesign1_48 = component(HFSSDesign1, 3D_Component_File_Path=C:/Users/vemana/Desktop/Modified_HELIOS_Footprint.a3dcomp, beta=beta76, dy=Len_76, alpha=alpha76, dz=Wid_76)
  Reflector_Element48 [copper] = part_of(HFSSDesign1_48) in module76
  HFSSDesign1_49 = component(HFSSDesign1, 3D_Component_File_Path=C:/Users/vemana/Desktop/Modified_HELIOS_Footprint.a3dcomp, beta=beta77, dy=Len_77, alpha=alpha77, dz=Wid_77)
  Reflector_Element49 [copper] = part_of(HFSSDesign1_49) in module77
boundaries and excitations:
  HFSSDesign1_1_SBRRegion1: Hybrid Region Objects=Reflector_Element Type=SBR+
  HFSSDesign1_1_FiniteCond1: Finite Conductivity Objects=Reflector_Element UseMaterial Material=HFSSDesign1_1:copper IsInternal
  HFSSDesign1_2_SBRRegion1: Hybrid Region Objects=Reflector_Element2 Type=SBR+
  HFSSDesign1_2_FiniteCond1: Finite Conductivity Objects=Reflector_Element2 UseMaterial Material=HFSSDesign1_2:copper IsInternal
  HFSSDesign1_3_SBRRegion1: Hybrid Region Objects=Reflector_Element3 Type=SBR+
  HFSSDesign1_3_FiniteCond1: Finite Conductivity Objects=Reflector_Element3 UseMaterial Material=HFSSDesign1_3:copper IsInternal
  HFSSDesign1_4_SBRRegion1: Hybrid Region Objects=Reflector_Element4 Type=SBR+
  HFSSDesign1_4_FiniteCond1: Finite Conductivity Objects=Reflector_Element4 UseMaterial Material=HFSSDesign1_4:copper IsInternal
  HFSSDesign1_5_SBRRegion1: Hybrid Region Objects=Reflector_Element5 Type=SBR+
  HFSSDesign1_5_FiniteCond1: Finite Conductivity Objects=Reflector_Element5 UseMaterial Material=HFSSDesign1_5:copper IsInternal
  HFSSDesign1_6_SBRRegion1: Hybrid Region Objects=Reflector_Element6 Type=SBR+
  HFSSDesign1_6_FiniteCond1: Finite Conductivity Objects=Reflector_Element6 UseMaterial Material=HFSSDesign1_6:copper IsInternal
  HFSSDesign1_7_SBRRegion1: Hybrid Region Objects=Reflector_Element7 Type=SBR+
  HFSSDesign1_7_FiniteCond1: Finite Conductivity Objects=Reflector_Element7 UseMaterial Material=HFSSDesign1_7:copper IsInternal
  HFSSDesign1_8_SBRRegion1: Hybrid Region Objects=Reflector_Element8 Type=SBR+
  HFSSDesign1_8_FiniteCond1: Finite Conductivity Objects=Reflector_Element8 UseMaterial Material=HFSSDesign1_8:copper IsInternal
  HFSSDesign1_9_SBRRegion1: Hybrid Region Objects=Reflector_Element9 Type=SBR+
  HFSSDesign1_9_FiniteCond1: Finite Conductivity Objects=Reflector_Element9 UseMaterial Material=HFSSDesign1_9:copper IsInternal
  HFSSDesign1_10_SBRRegion1: Hybrid Region Objects=Reflector_Element10 Type=SBR+
  HFSSDesign1_10_FiniteCond1: Finite Conductivity Objects=Reflector_Element10 UseMaterial Material=HFSSDesign1_10:copper IsInternal
  HFSSDesign1_11_SBRRegion1: Hybrid Region Objects=Reflector_Element11 Type=SBR+
  HFSSDesign1_11_FiniteCond1: Finite Conductivity Objects=Reflector_Element11 UseMaterial Material=HFSSDesign1_11:copper IsInternal
  HFSSDesign1_12_SBRRegion1: Hybrid Region Objects=Reflector_Element12 Type=SBR+
  HFSSDesign1_12_FiniteCond1: Finite Conductivity Objects=Reflector_Element12 UseMaterial Material=HFSSDesign1_12:copper IsInternal
  HFSSDesign1_13_SBRRegion1: Hybrid Region Objects=Reflector_Element13 Type=SBR+
  HFSSDesign1_13_FiniteCond1: Finite Conductivity Objects=Reflector_Element13 UseMaterial Material=HFSSDesign1_13:copper IsInternal
  HFSSDesign1_14_SBRRegion1: Hybrid Region Objects=Reflector_Element14 Type=SBR+
  HFSSDesign1_14_FiniteCond1: Finite Conductivity Objects=Reflector_Element14 UseMaterial Material=HFSSDesign1_14:copper IsInternal
  HFSSDesign1_15_SBRRegion1: Hybrid Region Objects=Reflector_Element15 Type=SBR+
  HFSSDesign1_15_FiniteCond1: Finite Conductivity Objects=Reflector_Element15 UseMaterial Material=HFSSDesign1_15:copper IsInternal
  HFSSDesign1_16_SBRRegion1: Hybrid Region Objects=Reflector_Element16 Type=SBR+
  HFSSDesign1_16_FiniteCond1: Finite Conductivity Objects=Reflector_Element16 UseMaterial Material=HFSSDesign1_16:copper IsInternal
  HFSSDesign1_17_SBRRegion1: Hybrid Region Objects=Reflector_Element17 Type=SBR+
  HFSSDesign1_17_FiniteCond1: Finite Conductivity Objects=Reflector_Element17 UseMaterial Material=HFSSDesign1_17:copper IsInternal
  HFSSDesign1_18_SBRRegion1: Hybrid Region Objects=Reflector_Element18 Type=SBR+
  HFSSDesign1_18_FiniteCond1: Finite Conductivity Objects=Reflector_Element18 UseMaterial Material=HFSSDesign1_18:copper IsInternal
  HFSSDesign1_19_SBRRegion1: Hybrid Region Objects=Reflector_Element19 Type=SBR+
  HFSSDesign1_19_FiniteCond1: Finite Conductivity Objects=Reflector_Element19 UseMaterial Material=HFSSDesign1_19:copper IsInternal
  HFSSDesign1_20_SBRRegion1: Hybrid Region Objects=Reflector_Element20 Type=SBR+
  HFSSDesign1_20_FiniteCond1: Finite Conductivity Objects=Reflector_Element20 UseMaterial Material=HFSSDesign1_20:copper IsInternal
  HFSSDesign1_21_SBRRegion1: Hybrid Region Objects=Reflector_Element21 Type=SBR+
  HFSSDesign1_21_FiniteCond1: Finite Conductivity Objects=Reflector_Element21 UseMaterial Material=HFSSDesign1_21:copper IsInternal
  HFSSDesign1_22_SBRRegion1: Hybrid Region Objects=Reflector_Element22 Type=SBR+
  HFSSDesign1_22_FiniteCond1: Finite Conductivity Objects=Reflector_Element22 UseMaterial Material=HFSSDesign1_22:copper IsInternal
  HFSSDesign1_23_SBRRegion1: Hybrid Region Objects=Reflector_Element23 Type=SBR+
  HFSSDesign1_23_FiniteCond1: Finite Conductivity Objects=Reflector_Element23 UseMaterial Material=HFSSDesign1_23:copper IsInternal
  HFSSDesign1_24_SBRRegion1: Hybrid Region Objects=Reflector_Element24 Type=SBR+
  HFSSDesign1_24_FiniteCond1: Finite Conductivity Objects=Reflector_Element24 UseMaterial Material=HFSSDesign1_24:copper IsInternal
  HFSSDesign1_25_SBRRegion1: Hybrid Region Objects=Reflector_Element25 Type=SBR+
  HFSSDesign1_25_FiniteCond1: Finite Conductivity Objects=Reflector_Element25 UseMaterial Material=HFSSDesign1_25:copper IsInternal
  HFSSDesign1_26_SBRRegion1: Hybrid Region Objects=Reflector_Element26 Type=SBR+
  HFSSDesign1_26_FiniteCond1: Finite Conductivity Objects=Reflector_Element26 UseMaterial Material=HFSSDesign1_26:copper IsInternal
  HFSSDesign1_27_SBRRegion1: Hybrid Region Objects=Reflector_Element27 Type=SBR+
  HFSSDesign1_27_FiniteCond1: Finite Conductivity Objects=Reflector_Element27 UseMaterial Material=HFSSDesign1_27:copper IsInternal
  HFSSDesign1_28_SBRRegion1: Hybrid Region Objects=Reflector_Element28 Type=SBR+
  HFSSDesign1_28_FiniteCond1: Finite Conductivity Objects=Reflector_Element28 UseMaterial Material=HFSSDesign1_28:copper IsInternal
  HFSSDesign1_29_SBRRegion1: Hybrid Region Objects=Reflector_Element29 Type=SBR+
  HFSSDesign1_29_FiniteCond1: Finite Conductivity Objects=Reflector_Element29 UseMaterial Material=HFSSDesign1_29:copper IsInternal
  HFSSDesign1_30_SBRRegion1: Hybrid Region Objects=Reflector_Element30 Type=SBR+
  HFSSDesign1_30_FiniteCond1: Finite Conductivity Objects=Reflector_Element30 UseMaterial Material=HFSSDesign1_30:copper IsInternal
  HFSSDesign1_31_SBRRegion1: Hybrid Region Objects=Reflector_Element31 Type=SBR+
  HFSSDesign1_31_FiniteCond1: Finite Conductivity Objects=Reflector_Element31 UseMaterial Material=HFSSDesign1_31:copper IsInternal
  HFSSDesign1_32_SBRRegion1: Hybrid Region Objects=Reflector_Element32 Type=SBR+
  HFSSDesign1_32_FiniteCond1: Finite Conductivity Objects=Reflector_Element32 UseMaterial Material=HFSSDesign1_32:copper IsInternal
  HFSSDesign1_33_SBRRegion1: Hybrid Region Objects=Reflector_Element33 Type=SBR+
  HFSSDesign1_33_FiniteCond1: Finite Conductivity Objects=Reflector_Element33 UseMaterial Material=HFSSDesign1_33:copper IsInternal
  HFSSDesign1_34_SBRRegion1: Hybrid Region Objects=Reflector_Element34 Type=SBR+
  HFSSDesign1_34_FiniteCond1: Finite Conductivity Objects=Reflector_Element34 UseMaterial Material=HFSSDesign1_34:copper IsInternal
  HFSSDesign1_35_SBRRegion1: Hybrid Region Objects=Reflector_Element35 Type=SBR+
  HFSSDesign1_35_FiniteCond1: Finite Conductivity Objects=Reflector_Element35 UseMaterial Material=HFSSDesign1_35:copper IsInternal
  HFSSDesign1_36_SBRRegion1: Hybrid Region Objects=Reflector_Element36 Type=SBR+
  HFSSDesign1_36_FiniteCond1: Finite Conductivity Objects=Reflector_Element36 UseMaterial Material=HFSSDesign1_36:copper IsInternal
  HFSSDesign1_37_SBRRegion1: Hybrid Region Objects=Reflector_Element37 Type=SBR+
  HFSSDesign1_37_FiniteCond1: Finite Conductivity Objects=Reflector_Element37 UseMaterial Material=HFSSDesign1_37:copper IsInternal
  HFSSDesign1_38_SBRRegion1: Hybrid Region Objects=Reflector_Element38 Type=SBR+
  HFSSDesign1_38_FiniteCond1: Finite Conductivity Objects=Reflector_Element38 UseMaterial Material=HFSSDesign1_38:copper IsInternal
  HFSSDesign1_39_SBRRegion1: Hybrid Region Objects=Reflector_Element39 Type=SBR+
  HFSSDesign1_39_FiniteCond1: Finite Conductivity Objects=Reflector_Element39 UseMaterial Material=HFSSDesign1_39:copper IsInternal
  HFSSDesign1_40_SBRRegion1: Hybrid Region Objects=Reflector_Element40 Type=SBR+
  HFSSDesign1_40_FiniteCond1: Finite Conductivity Objects=Reflector_Element40 UseMaterial Material=HFSSDesign1_40:copper IsInternal
  HFSSDesign1_41_SBRRegion1: Hybrid Region Objects=Reflector_Element41 Type=SBR+
  HFSSDesign1_41_FiniteCond1: Finite Conductivity Objects=Reflector_Element41 UseMaterial Material=HFSSDesign1_41:copper IsInternal
  HFSSDesign1_42_SBRRegion1: Hybrid Region Objects=Reflector_Element42 Type=SBR+
  HFSSDesign1_42_FiniteCond1: Finite Conductivity Objects=Reflector_Element42 UseMaterial Material=HFSSDesign1_42:copper IsInternal
  HFSSDesign1_43_SBRRegion1: Hybrid Region Objects=Reflector_Element43 Type=SBR+
  HFSSDesign1_43_FiniteCond1: Finite Conductivity Objects=Reflector_Element43 UseMaterial Material=HFSSDesign1_43:copper IsInternal
  HFSSDesign1_44_SBRRegion1: Hybrid Region Objects=Reflector_Element44 Type=SBR+
  HFSSDesign1_44_FiniteCond1: Finite Conductivity Objects=Reflector_Element44 UseMaterial Material=HFSSDesign1_44:copper IsInternal
  HFSSDesign1_45_SBRRegion1: Hybrid Region Objects=Reflector_Element45 Type=SBR+
  HFSSDesign1_45_FiniteCond1: Finite Conductivity Objects=Reflector_Element45 UseMaterial Material=HFSSDesign1_45:copper IsInternal
  HFSSDesign1_46_SBRRegion1: Hybrid Region Objects=Reflector_Element46 Type=SBR+
  HFSSDesign1_46_FiniteCond1: Finite Conductivity Objects=Reflector_Element46 UseMaterial Material=HFSSDesign1_46:copper IsInternal
  HFSSDesign1_47_SBRRegion1: Hybrid Region Objects=Reflector_Element47 Type=SBR+
  HFSSDesign1_47_FiniteCond1: Finite Conductivity Objects=Reflector_Element47 UseMaterial Material=HFSSDesign1_47:copper IsInternal
  HFSSDesign1_48_SBRRegion1: Hybrid Region Objects=Reflector_Element48 Type=SBR+
  HFSSDesign1_48_FiniteCond1: Finite Conductivity Objects=Reflector_Element48 UseMaterial Material=HFSSDesign1_48:copper IsInternal
  HFSSDesign1_49_SBRRegion1: Hybrid Region Objects=Reflector_Element49 Type=SBR+
  HFSSDesign1_49_FiniteCond1: Finite Conductivity Objects=Reflector_Element49 UseMaterial Material=HFSSDesign1_49:copper IsInternal
  IncPWave1: Plane Incident Wave PhiStart="(180+az_angle*180/pi) deg" PhiStop="(180+az_angle*180/pi) deg" PhiPoints=1 ThetaStart="-el_angle*180/pi deg" ThetaStop="-el_angle*180/pi deg" ThetaPoints=1 EoPhi=1 EoTheta=0 OriginX=spacing_x OriginY=spacing_y OriginZ=spacing_z IsPropagating
mesh:
  HFSSDesign1_1_SBRCurvExtr1: CurvatureExtraction Objects=Reflector_Element DisableForFacetedSurfaces
  HFSSDesign1_2_SBRCurvExtr1: CurvatureExtraction Objects=Reflector_Element2 DisableForFacetedSurfaces
  HFSSDesign1_3_SBRCurvExtr1: CurvatureExtraction Objects=Reflector_Element3 DisableForFacetedSurfaces
  HFSSDesign1_4_SBRCurvExtr1: CurvatureExtraction Objects=Reflector_Element4 DisableForFacetedSurfaces
  HFSSDesign1_5_SBRCurvExtr1: CurvatureExtraction Objects=Reflector_Element5 DisableForFacetedSurfaces
  HFSSDesign1_6_SBRCurvExtr1: CurvatureExtraction Objects=Reflector_Element6 DisableForFacetedSurfaces
  HFSSDesign1_7_SBRCurvExtr1: CurvatureExtraction Objects=Reflector_Element7 DisableForFacetedSurfaces
  HFSSDesign1_8_SBRCurvExtr1: CurvatureExtraction Objects=Reflector_Element8 DisableForFacetedSurfaces
  HFSSDesign1_9_SBRCurvExtr1: CurvatureExtraction Objects=Reflector_Element9 DisableForFacetedSurfaces
  HFSSDesign1_10_SBRCurvExtr1: CurvatureExtraction Objects=Reflector_Element10 DisableForFacetedSurfaces
  HFSSDesign1_11_SBRCurvExtr1: CurvatureExtraction Objects=Reflector_Element11 DisableForFacetedSurfaces
  HFSSDesign1_12_SBRCurvExtr1: CurvatureExtraction Objects=Reflector_Element12 DisableForFacetedSurfaces
  HFSSDesign1_13_SBRCurvExtr1: CurvatureExtraction Objects=Reflector_Element13 DisableForFacetedSurfaces
  HFSSDesign1_14_SBRCurvExtr1: CurvatureExtraction Objects=Reflector_Element14 DisableForFacetedSurfaces
  HFSSDesign1_15_SBRCurvExtr1: CurvatureExtraction Objects=Reflector_Element15 DisableForFacetedSurfaces
  HFSSDesign1_16_SBRCurvExtr1: CurvatureExtraction Objects=Reflector_Element16 DisableForFacetedSurfaces
  HFSSDesign1_17_SBRCurvExtr1: CurvatureExtraction Objects=Reflector_Element17 DisableForFacetedSurfaces
  HFSSDesign1_18_SBRCurvExtr1: CurvatureExtraction Objects=Reflector_Element18 DisableForFacetedSurfaces
  HFSSDesign1_19_SBRCurvExtr1: CurvatureExtraction Objects=Reflector_Element19 DisableForFacetedSurfaces
  HFSSDesign1_20_SBRCurvExtr1: CurvatureExtraction Objects=Reflector_Element20 DisableForFacetedSurfaces
  HFSSDesign1_21_SBRCurvExtr1: CurvatureExtraction Objects=Reflector_Element21 DisableForFacetedSurfaces
  HFSSDesign1_22_SBRCurvExtr1: CurvatureExtraction Objects=Reflector_Element22 DisableForFacetedSurfaces
  HFSSDesign1_23_SBRCurvExtr1: CurvatureExtraction Objects=Reflector_Element23 DisableForFacetedSurfaces
  HFSSDesign1_24_SBRCurvExtr1: CurvatureExtraction Objects=Reflector_Element24 DisableForFacetedSurfaces
  HFSSDesign1_25_SBRCurvExtr1: CurvatureExtraction Objects=Reflector_Element25 DisableForFacetedSurfaces
  HFSSDesign1_26_SBRCurvExtr1: CurvatureExtraction Objects=Reflector_Element26 DisableForFacetedSurfaces
  HFSSDesign1_27_SBRCurvExtr1: CurvatureExtraction Objects=Reflector_Element27 DisableForFacetedSurfaces
  HFSSDesign1_28_SBRCurvExtr1: CurvatureExtraction Objects=Reflector_Element28 DisableForFacetedSurfaces
  HFSSDesign1_29_SBRCurvExtr1: CurvatureExtraction Objects=Reflector_Element29 DisableForFacetedSurfaces
  HFSSDesign1_30_SBRCurvExtr1: CurvatureExtraction Objects=Reflector_Element30 DisableForFacetedSurfaces
  HFSSDesign1_31_SBRCurvExtr1: CurvatureExtraction Objects=Reflector_Element31 DisableForFacetedSurfaces
  HFSSDesign1_32_SBRCurvExtr1: CurvatureExtraction Objects=Reflector_Element32 DisableForFacetedSurfaces
  HFSSDesign1_33_SBRCurvExtr1: CurvatureExtraction Objects=Reflector_Element33 DisableForFacetedSurfaces
  HFSSDesign1_34_SBRCurvExtr1: CurvatureExtraction Objects=Reflector_Element34 DisableForFacetedSurfaces
  HFSSDesign1_35_SBRCurvExtr1: CurvatureExtraction Objects=Reflector_Element35 DisableForFacetedSurfaces
  HFSSDesign1_36_SBRCurvExtr1: CurvatureExtraction Objects=Reflector_Element36 DisableForFacetedSurfaces
  HFSSDesign1_37_SBRCurvExtr1: CurvatureExtraction Objects=Reflector_Element37 DisableForFacetedSurfaces
  HFSSDesign1_38_SBRCurvExtr1: CurvatureExtraction Objects=Reflector_Element38 DisableForFacetedSurfaces
  HFSSDesign1_39_SBRCurvExtr1: CurvatureExtraction Objects=Reflector_Element39 DisableForFacetedSurfaces
  HFSSDesign1_40_SBRCurvExtr1: CurvatureExtraction Objects=Reflector_Element40 DisableForFacetedSurfaces
  HFSSDesign1_41_SBRCurvExtr1: CurvatureExtraction Objects=Reflector_Element41 DisableForFacetedSurfaces
  HFSSDesign1_42_SBRCurvExtr1: CurvatureExtraction Objects=Reflector_Element42 DisableForFacetedSurfaces
  HFSSDesign1_43_SBRCurvExtr1: CurvatureExtraction Objects=Reflector_Element43 DisableForFacetedSurfaces
  HFSSDesign1_44_SBRCurvExtr1: CurvatureExtraction Objects=Reflector_Element44 DisableForFacetedSurfaces
  HFSSDesign1_45_SBRCurvExtr1: CurvatureExtraction Objects=Reflector_Element45 DisableForFacetedSurfaces
  HFSSDesign1_46_SBRCurvExtr1: CurvatureExtraction Objects=Reflector_Element46 DisableForFacetedSurfaces
  HFSSDesign1_47_SBRCurvExtr1: CurvatureExtraction Objects=Reflector_Element47 DisableForFacetedSurfaces
  HFSSDesign1_48_SBRCurvExtr1: CurvatureExtraction Objects=Reflector_Element48 DisableForFacetedSurfaces
  HFSSDesign1_49_SBRCurvExtr1: CurvatureExtraction Objects=Reflector_Element49 DisableForFacetedSurfaces
setups:
  Setup1: HfssDriven RayDensityPerWavelength=4 MaxNumberOfBounces=5 RadiationSetup=119 PTDUTDSimulationSettings="PTD Correction + UTD Rays" PTDEdgeDensity=20 ComputeFarFields
    sweep Sweep: point 28GHz;
source amplitudes:
  IncPWave1:1: 1 0deg
radiation setups:
  FarField_Setup: Infinite Sphere Theta=0deg..180deg step 1deg Phi=-90deg..90deg step 1deg CoordSystem=module11
reports:
  FarField_Report: dB(RCSTotal) vs Phi, Theta on Setup1 : Sweep, FarField_Setup [Freq=28GHz IWavePhi=180deg IWaveTheta=-90deg]
