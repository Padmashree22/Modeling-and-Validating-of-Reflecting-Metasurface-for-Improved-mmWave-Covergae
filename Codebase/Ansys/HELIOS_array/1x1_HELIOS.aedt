# Ansys Electronics Desktop project, version 2021.2
materials:
  vacuum: permittivity=1
  pec: conductivity=1e+30

design HFSSDesign1 (HFSS, SBR+, model units mm)
variables:
  alpha11 = 0.01deg
  beta11 = 0.01deg
  Len_11 = Length
  Wid_11 = Width
  spacing_magnitude = 1meter
  el_angle = 90deg
  az_angle = 90deg
  spacing_x = spacing_magnitude*sin(el_angle*pi/180 deg)*cos(az_angle*pi/180 deg)
  spacing_y = spacing_magnitude*sin(el_angle*pi/180 deg)*sin(-1*az_angle*pi/180 deg)
  spacing_z = spacing_magnitude*cos(el_angle*pi/180 deg)
  Length = 10cm
  Width = 10cm
geometry:
  coordinate_system module11 = origin=(0mm, 0mm, 0mm) x=(1mm, 0mm, 0mm) y=(0mm, 1mm, 0mm)
  HFSSDesign1_1 = component(HFSSDesign1, 3D_Component_File_Path=C:/Users/vemana/Desktop/Modified_HELIOS_Footprint.a3dcomp, dy=Len_11, dz=Wid_11, beta=beta11, alpha=alpha11)
  Reflector_Element [copper] = part_of(HFSSDesign1_1) in module11
boundaries and excitations:
  HFSSDesign1_1_SBRRegion1: Hybrid Region Objects=Reflector_Element Type=SBR+
  HFSSDesign1_1_FiniteCond1: Finite Conductivity Objects=Reflector_Element UseMaterial Material=HFSSDesign1_1:copper IsInternal
  IncPWave1: Plane Incident Wave PhiStart=180+az_angle*180/pi PhiStop=180+az_angle*180/pi PhiPoints=1 ThetaStart=-el_angle*180/pi ThetaStop=-el_angle*180/pi ThetaPoints=1 EoPhi=1 EoTheta=0 OriginX=spacing_x OriginY=spacing_y OriginZ=spacing_z IsPropagating
mesh:
  HFSSDesign1_1_SBRCurvExtr1: CurvatureExtraction Objects=Reflector_Element DisableForFacetedSurfaces
setups:
  Setup1: HfssDriven RayDensityPerWavelength=4 MaxNumberOfBounces=5 RadiationSetup=189 PTDUTDSimulationSettings="PTD Correction + UTD Rays" PTDEdgeDensity=20 ComputeFarFields
    sweep Sweep: point 28GHz;
source amplitudes:
  IncPWave1:1: 1 0deg
radiation setups:
  FarField_Setup: Infinite Sphere Theta=0deg..180deg step 1deg Phi=-90deg..90deg step 1deg
reports:
  FarField_Report: dB(RCSTotal) vs Phi, Theta on Setup1 : Sweep, FarField_Setup [Freq=28GHz IWavePhi=180deg IWaveTheta=-90deg]
