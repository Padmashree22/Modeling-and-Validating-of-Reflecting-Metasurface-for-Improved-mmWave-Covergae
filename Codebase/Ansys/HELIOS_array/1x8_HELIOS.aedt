# Ansys Electronics Desktop project, version 2021.2
materials:
  vacuum: permittivity=1
  pec: conductivity=1e+30

design HFSSDesign1 (HFSS, SBR+, model units mm)
variables:
  alpha11 = 10deg
  beta11 = 10deg
  Len_11 = Length
  Wid_11 = Width
  spacing_magnitude = 1meter
  el_angle = 100deg
  az_angle = 10deg
  spacing_x = spacing_magnitude*sin(el_angle*pi/180 deg)*cos(az_angle*pi/180 deg)
  spacing_y = spacing_magnitude*sin(el_angle*pi/180 deg)*sin(-1*az_angle*pi/180 deg)
  spacing_z = spacing_magnitude*cos(el_angle*pi/180 deg)
  Length = 10cm
  Width = 10cm
  alpha12 = alpha11
  beta12 = beta11
  Len_12 = Len_11
  Wid_12 = Wid_11
  alpha13 = alpha12
  beta13 = beta12
  Len_13 = Len_12
  Wid_13 = Wid_12
  alpha14 = alpha13
  beta14 = beta13
  Len_14 = Len_13
  Wid_14 = Wid_13
  alpha15 = alpha14
  beta15 = beta14
  Len_15 = Len_14
  Wid_15 = Wid_14
  alpha16 = alpha15
  beta16 = beta15
  Len_16 = Len_15
  Wid_16 = Wid_15
  alpha17 = alpha16
  beta17 = beta16
  Len_17 = Len_16
  Wid_17 = Wid_16
  alpha18 = alpha17
  beta18 = beta17
  Len_18 = Len_17
  Wid_18 = Wid_17
geometry:
  coordinate_system module11 = origin=(0mm, 0mm, 0mm) x=(1mm, 0mm, 0mm) y=(0mm, 1mm, 0mm)
  coordinate_system module12 = origin=(0mm, Length, 0mm) x=(1mm, 0mm, 0mm) y=(0mm, 1mm, 0mm)
  coordinate_system module13 = origin=(0mm, 2*Length, 0mm) x=(1mm, 0mm, 0mm) y=(0mm, 1mm, 0mm)
  coordinate_system module14 = origin=(0mm, 3*Length, 0mm) x=(1mm, 0mm, 0mm) y=(0mm, 1mm, 0mm)
  coordinate_system module15 = origin=(0mm, 4*Length, 0mm) x=(1mm, 0mm, 0mm) y=(0mm, 1mm, 0mm)
  coordinate_system module16 = origin=(0mm, 5*Length, 0mm) x=(1mm, 0mm, 0mm) y=(0mm, 1mm, 0mm)
  coordinate_system module17 = origin=(0mm, 6*Length, 0mm) x=(1mm, 0mm, 0mm) y=(0mm, 1mm, 0mm)
  coordinate_system module18 = origin=(0mm, 7*Length, 0mm) x=(1mm, 0mm, 0mm) y=(0mm, 1mm, 0mm)
  HFSSDesign1_1 = component(HFSSDesign1, 3D_Component_File_Path=C:/Users/vemana/Desktop/Modified_HELIOS_Footprint.a3dcomp, beta=beta11, dy=Len_11, alpha=alpha11, dz=Wid_11)
  Reflector_Element [copper] = part_of(HFSSDesign1_1) in module11
  HFSSDesign1_2 = component(HFSSDesign1, 3D_Component_File_Path=C:/Users/vemana/Desktop/Modified_HELIOS_Footprint.a3dcomp, beta=beta12, dy=Len_12, alpha=alpha12, dz=Wid_12)
  Reflector_Element2 [copper] = part_of(HFSSDesign1_2) in module12
  HFSSDesign1_3 = component(HFSSDesign1, 3D_Component_File_Path=C:/Users/vemana/Desktop/Modified_HELIOS_Footprint.a3dcomp, beta=beta13, dy=Len_13, alpha=alpha13, dz=Wid_13)
  Reflector_Element3 [copper] = part_of(HFSSDesign1_3) in module13
  HFSSDesign1_4 = component(HFSSDesign1, 3D_Component_File_Path=C:/Users/vemana/Desktop/Modified_HELIOS_Footprint.a3dcomp, beta=beta14, dy=Len_14, alpha=alpha14, dz=Wid_14)
  Reflector_Element4 [copper] = part_of(HFSSDesign1_4) in module14
  HFSSDesign1_5 = component(HFSSDesign1, 3D_Component_File_Path=C:/Users/vemana/Desktop/Modified_HELIOS_Footprint.a3dcomp, beta=beta15, dy=Len_15, alpha=alpha15, dz=Wid_15)
  Reflector_Element5 [copper] = part_of(HFSSDesign1_5) in module15
  HFSSDesign1_6 = component(HFSSDesign1, 3D_Component_File_Path=C:/Users/vemana/Desktop/Modified_HELIOS_Footprint.a3dcomp, beta=beta16, dy=Len_16, alpha=alpha16, dz=Wid_16)
  Reflector_Element6 [copper] = part_of(HFSSDesign1_6) in module16
  HFSSDesign1_7 = component(HFSSDesign1, 3D_Component_File_Path=C:/Users/vemana/Desktop/Modified_HELIOS_Footprint.a3dcomp, beta=beta17, dy=Len_17, alpha=alpha17, dz=Wid_17)
  Reflector_Element7 [copper] = part_of(HFSSDesign1_7) in module17
  HFSSDesign1_8 = component(HFSSDesign1, 3D_Component_File_Path=C:/Users/vemana/Desktop/Modified_HELIOS_Footprint.a3dcomp, beta=beta18, dy=Len_18, alpha=alpha18, dz=Wid_18)
  Reflector_Element8 [copper] = part_of(HFSSDesign1_8) in module18
boundaries and excitations:
  HFSSDesign1_1_SBRRegion1: Hybrid Region Objects=Reflector_Element Type=SBR+
  HFSSDesign1_1_FiniteCond1: Finite Conductivity Objects=Reflector_Element UseMaterial Material=HFSSDesign1_1:copper IsInternal
  HFSSDesign1_2_SBRRegion1: Hybrid Region Objects=Reflector_Element2 Type=SBR+
  HFSSDesign1_2_FiniteCond1: Finite Conductivity Objects=Reflector_Element2 UseMaterial Material=HFSSDesign1_2:copper IsInternal
  HFSSDesign1_3_SBRRegion1: Hybrid Region Objects=Reflector_Element3 Type=SBR+
  HFSSDesign1_3_FiniteCond1: Finite Conductivity Objects=Reflector_Element3 UseMaterial Material=HFSSDesign1_3:copper IsInternal
  HFSSDesign1_4_SBRRegion1: Hybrid Region Objects=Reflector_Element4 Type=SBR+
  HFSSDesign1_4_FiniteCond1: Finite Conductivity Objects=Reflector_Element4 UseMaterial Material=HFSSDesign1_4:copper IsInternal
  HFSSDesign1_5_SBRRegion1: Hybrid Region Objects=Reflector_Element5 Type=SBR+
  HFSSDesign1_5_FiniteCond1: Finite Conductivity Objects=Reflector_Element5 UseMaterial Material=HFSSDesign1_5:copper IsInternal
  HFSSDesign1_6_SBRRegion1: Hybrid Region Objects=Reflector_Element6 Type=SBR+
  HFSSDesign1_6_FiniteCond1: Finite Conductivity Objects=Reflector_Element6 UseMaterial Material=HFSSDesign1_6:copper IsInternal
  HFSSDesign1_7_SBRRegion1: Hybrid Region Objects=Reflector_Element7 Type=SBR+
  HFSSDesign1_7_FiniteCond1: Finite Conductivity Objects=Reflector_Element7 UseMaterial Material=HFSSDesign1_7:copper IsInternal
  HFSSDesign1_8_SBRRegion1: Hybrid Region Objects=Reflector_Element8 Type=SBR+
  HFSSDesign1_8_FiniteCond1: Finite Conductivity Objects=Reflector_Element8 UseMaterial Material=HFSSDesign1_8:copper IsInternal
  IncPWave1: Plane Incident Wave PhiStart="(180+az_angle*180/pi) deg" PhiStop="(180+az_angle*180/pi) deg" PhiPoints=1 ThetaStart="-el_angle*180/pi deg" ThetaStop="-el_angle*180/pi deg" ThetaPoints=1 EoPhi=1 EoTheta=0 OriginX=spacing_x OriginY=spacing_y OriginZ=spacing_z IsPropagating
mesh:
  HFSSDesign1_1_SBRCurvExtr1: CurvatureExtraction Objects=Reflector_Element DisableForFacetedSurfaces
  HFSSDesign1_2_SBRCurvExtr1: CurvatureExtraction Objects=Reflector_Element2 DisableForFacetedSurfaces
  HFSSDesign1_3_SBRCurvExtr1: CurvatureExtraction Objects=Reflector_Element3 DisableForFacetedSurfaces
  HFSSDesign1_4_SBRCurvExtr1: CurvatureExtraction Objects=Reflector_Element4 DisableForFacetedSurfaces
  HFSSDesign1_5_SBRCurvExtr1: CurvatureExtraction Objects=Reflector_Element5 DisableForFacetedSurfaces
  HFSSDesign1_6_SBRCurvExtr1: CurvatureExtraction Objects=Reflector_Element6 DisableForFacetedSurfaces
  HFSSDesign1_7_SBRCurvExtr1: CurvatureExtraction Objects=Reflector_Element7 DisableForFacetedSurfaces
  HFSSDesign1_8_SBRCurvExtr1: CurvatureExtraction Objects=Reflector_Element8 DisableForFacetedSurfaces
setups:
  Setup1: HfssDriven RayDensityPerWavelength=4 MaxNumberOfBounces=5 RadiationSetup=25 PTDUTDSimulationSettings="PTD Correction + UTD Rays" PTDEdgeDensity=20 ComputeFarFields
    sweep Sweep: point 28GHz;
source amplitudes:
  IncPWave1:1: 1 0deg
radiation setups:
  FarField_Setup: Infinite Sphere Theta=0deg..180deg step 1deg Phi=-90deg..90deg step 1deg CoordSystem=module11
reports:
  FarField_Report: dB(RCSTotal) vs Phi, Theta on Setup1 : Sweep, FarField_Setup [Freq=28GHz IWavePhi=180deg IWaveTheta=-90deg]
