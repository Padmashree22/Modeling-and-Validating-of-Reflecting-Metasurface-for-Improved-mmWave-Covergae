# Ansys Electronics Desktop project, version 2021.2
materials:
  vacuum: permittivity=1
  pec: conductivity=1e+30

design HFSSDesign1 (HFSS, SBR+, model units mm)
variables:
  Length = 20cm
  Width = 20cm
  alpha11 = 0.2deg
  beta11 = 0.1deg
  Len_11 = Length
  Wid_11 = Width
  alpha12 = alpha11
  beta12 = beta11
  Len_12 = Len_11
  Wid_12 = Wid_11
  alpha21 = alpha11
  beta21 = beta11
  Len_21 = Len_11
  Wid_21 = Wid_11
  alpha22 = alpha12
  beta22 = beta12
  Len_22 = Len_12
  Wid_22 = Wid_12
  spacing_magnitude = 1meter
  el_angle = 90deg
  az_angle = 0deg
  spacing_x = spacing_magnitude*sin(el_angle*pi/180 deg)*cos(az_angle*pi/180 deg)
  spacing_y = spacing_magnitude*sin(el_angle*pi/180 deg)*sin(-1*az_angle*pi/180 deg)
  spacing_z = spacing_magnitude*cos(el_angle*pi/180 deg)
geometry:
  coordinate_system module11 = origin=(0mm, 0mm, 0mm) x=(1mm, 0mm, 0mm) y=(0mm, 1mm, 0mm)
  coordinate_system module12 = origin=(0mm, Length, 0mm) x=(1mm, 0mm, 0mm) y=(0mm, 1mm, 0mm)
  coordinate_system module21 = origin=(0mm, 0mm, Width) x=(1mm, 0mm, 0mm) y=(0mm, 1mm, 0mm)
  coordinate_system module22 = origin=(0mm, Length, Width) x=(1mm, 0mm, 0mm) y=(0mm, 1mm, 0mm)
  HFSSDesign1_1 = component(HFSSDesign1, 3D_Component_File_Path=C:/Users/vemana/Desktop/alphabeta_HELIOS_Footprint.a3dcomp, alpha=alpha11, dz=Wid_11, dy=Len_11, beta=beta11)
  Reflector_Element [copper] = part_of(HFSSDesign1_1) in module11
  HFSSDesign1_2 = component(HFSSDesign1, 3D_Component_File_Path=C:/Users/vemana/Desktop/alphabeta_HELIOS_Footprint.a3dcomp, alpha=alpha12, dz=Wid_12, dy=Len_12, beta=beta12)
  Reflector_Element2 [copper] = part_of(HFSSDesign1_2) in module12
  HFSSDesign1_3 = component(HFSSDesign1, 3D_Component_File_Path=C:/Users/vemana/Desktop/alphabeta_HELIOS_Footprint.a3dcomp, alpha=alpha21, dz=Wid_21, dy=Len_21, beta=beta21)
  Reflector_Element3 [copper] = part_of(HFSSDesign1_3) in module21
  HFSSDesign1_4 = component(HFSSDesign1, 3D_Component_File_Path=C:/Users/vemana/Desktop/alphabeta_HELIOS_Footprint.a3dcomp, alpha=alpha22, dz=Wid_22, dy=Len_22, beta=beta22)
  Reflector_Element4 [copper] = part_of(HFSSDesign1_4) in module22
boundaries and excitations:
  HFSSDesign1_1_SBRRegion1: Hybrid Region Objects=Reflector_Element Type=SBR+
  HFSSDesign1_1_FiniteCond1: Finite Conductivity Objects=Reflector_Element UseMaterial Material=HFSSDesign1_1:copper IsInternal
  HFSSDesign1_2_SBRRegion1: Hybrid Region Objects=Reflector_Element2 Type=SBR+
  HFSSDesign1_2_FiniteCond1: Finite Conductivity Objects=Reflector_Element2 UseMaterial Material=HFSSDesign1_2:copper IsInternal
  HFSSDesign1_3_SBRRegion1: Hybrid Region Objects=Reflector_Element3 Type=SBR+
  HFSSDesign1_3_FiniteCond1: Finite Conductivity Objects=Reflector_Element3 UseMaterial Material=HFSSDesign1_3:copper IsInternal
  HFSSDesign1_4_SBRRegion1: Hybrid Region Objects=Reflector_Element4 Type=SBR+
  HFSSDesign1_4_FiniteCond1: Finite Conductivity Objects=Reflector_Element4 UseMaterial Material=HFSSDesign1_4:copper IsInternal
  IncPWave1: Plane Incident Wave PhiStart=180+az_angle*180/pi PhiStop=180+az_angle*180/pi PhiPoints=1 ThetaStart=-el_angle*180/pi ThetaStop=-el_angle*180/pi ThetaPoints=1 EoPhi=1 EoTheta=0 OriginX=spacing_x OriginY=spacing_y OriginZ=spacing_z IsPropagating
setups:
  Setup1: HfssDriven RayDensityPerWavelength=4 MaxNumberOfBounces=5 RadiationSetup=1 PTDUTDSimulationSettings="PTD Correction + UTD Rays" PTDEdgeDensity=20 ComputeFarFields
    sweep Sweep: point 28GHz;
source amplitudes:
  IncPWave1:1: 1 0deg
radiation setups:
  FarField_Setup: Infinite Sphere Theta=0deg..180deg step 1deg Phi=-90deg..90deg step 1deg
reports:
  FarField_Report: dB(RCSTotal) vs Phi, Theta on Setup1 : Sweep, FarField_Setup [Freq=28GHz IWavePhi=10313.2deg IWaveTheta=-5156.62deg]
