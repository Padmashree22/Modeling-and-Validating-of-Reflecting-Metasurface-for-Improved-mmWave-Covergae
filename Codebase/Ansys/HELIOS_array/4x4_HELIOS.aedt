# Ansys Electronics Desktop project, version 2021.2
materials:
  vacuum: permittivity=1
  pec: conductivity=1e+30

design HFSSDesign1 (HFSS, SBR+, model units mm)
variables:
  alpha11 = 0.2deg
  beta11 = 0.1deg
  Len_11 = Length
  Wid_11 = Width
  spacing_magnitude = 1meter
  el_angle = 90deg
  az_angle = 0deg
  spacing_x = spacing_magnitude*sin(el_angle*pi/180 deg)*cos(az_angle*pi/180 deg)
  spacing_y = spacing_magnitude*sin(el_angle*pi/180 deg)*sin(-1*az_angle*pi/180 deg)
  spacing_z = spacing_magnitude*cos(el_angle*pi/180 deg)
  Length = 10cm
  Width = 10cm
  alpha12 = alpha11
  beta12 = beta11
  Len_12 = Len_11
  Wid_12 = Wid_11
  alpha21 = alpha11
  beta21 = beta11
  Len_21 = Len_11
  Wid_21 = Wid_11
  alpha22 = alpha12
  beta22 = beta12
  Len_22 = Len_12
  Wid_22 = Wid_12
  Len_13 = Len_12
  alpha13 = alpha12
  beta13 = beta12
  Wid_13 = Wid_12
  alpha23 = alpha13
  beta23 = beta13
  Len_23 = Len_13
  Wid_23 = Wid_13
  alpha31 = alpha21
  beta31 = beta21
  Len_31 = Len_21
  Wid_31 = Wid_21
  alpha32 = alpha22
  beta32 = beta22
  Len_32 = Len_22
  Wid_32 = WId_22
  alpha33 = alpha23
  beta33 = beta23
  Len_33 = Len_23
  Wid_33 = Wid_23
  beta14 = beta13
  Len_14 = Len_13
  Wid_14 = Wid_13
  alpha14 = alpha13
  alpha24 = alpha14
  beta24 = beta14
  Len_24 = Len_14
  Wid_24 = Wid_14
  alpha34 = alpha24
  beta34 = beta24
  Len_34 = Len_24
  Wid_34 = Wid_24
  alpha41 = alpha31
  beta41 = beta31
  Len_41 = Len_31
  Wid_41 = Wid_31
  alpha42 = alpha32
  beta42 = beta32
  Len_42 = Len_32
  Wid_42 = Wid_32
  alpha43 = alpha33
  beta43 = beta33
  Len_43 = Len_33
  Wid_43 = Wid_33
  alpha44 = alpha34
  beta44 = beta34
  Len_44 = Len_34
  Wid_44 = Wid_34
geometry:
  coordinate_system module11 = origin=(0mm, 0mm, 0mm) x=(1mm, 0mm, 0mm) y=(0mm, 1mm, 0mm)
  coordinate_system module12 = origin=(0mm, Length, 0mm) x=(1mm, 0mm, 0mm) y=(0mm, 1mm, 0mm)
  coordinate_system module21 = origin=(0mm, 0mm, Width) x=(1mm, 0mm, 0mm) y=(0mm, 1mm, 0mm)
  coordinate_system module22 = origin=(0mm, Length, Width) x=(1mm, 0mm, 0mm) y=(0mm, 1mm, 0mm)
  coordinate_system module13 = origin=(0mm, 2*Length, 0mm) x=(1mm, 0mm, 0mm) y=(0mm, 1mm, 0mm)
  coordinate_system module23 = origin=(0mm, 2*Length, Width) x=(1mm, 0mm, 0mm) y=(0mm, 1mm, 0mm)
  coordinate_system module31 = origin=(0mm, 0mm, 2*Width) x=(1mm, 0mm, 0mm) y=(0mm, 1mm, 0mm)
  coordinate_system module32 = origin=(0mm, Length, 2*Width) x=(1mm, 0mm, 0mm) y=(0mm, 1mm, 0mm)
  coordinate_system module33 = origin=(0mm, 2*Length, 2*Width) x=(1mm, 0mm, 0mm) y=(0mm, 1mm, 0mm)
  coordinate_system module14 = origin=(0mm, 3*Length, 0mm) x=(1mm, 0mm, 0mm) y=(0mm, 1mm, 0mm)
  coordinate_system module24 = origin=(0mm, 3*Length, Width) x=(1mm, 0mm, 0mm) y=(0mm, 1mm, 0mm)
  coordinate_system module34 = origin=(0mm, 3*Length, 2*Width) x=(1mm, 0mm, 0mm) y=(0mm, 1mm, 0mm)
  coordinate_system module41 = origin=(0mm, 0mm, 3*Width) x=(1mm, 0mm, 0mm) y=(0mm, 1mm, 0mm)
  coordinate_system module42 = origin=(0mm, Length, 3*Width) x=(1mm, 0mm, 0mm) y=(0mm, 1mm, 0mm)
  coordinate_system module43 = origin=(0mm, 2*Length, 3*Width) x=(1mm, 0mm, 0mm) y=(0mm, 1mm, 0mm)
  coordinate_system module44 = origin=(0mm, 3*Length, 3*Width) x=(1mm, 0mm, 0mm) y=(0mm, 1mm, 0mm)
  HFSSDesign1_1 = component(HFSSDesign1, 3D_Component_File_Path=C:/Users/vemana/Desktop/alphabeta_HELIOS_Footprint.a3dcomp, dz=Wid_11, dy=Len_11, alpha=alpha11, beta=beta11)
  Reflector_Element [copper] = part_of(HFSSDesign1_1) in module11
  HFSSDesign1_2 = component(HFSSDesign1, 3D_Component_File_Path=C:/Users/vemana/Desktop/alphabeta_HELIOS_Footprint.a3dcomp, dz=Wid_12, dy=Len_12, alpha=alpha12, beta=beta12)
  Reflector_Element2 [copper] = part_of(HFSSDesign1_2) in module12
  HFSSDesign1_3 = component(HFSSDesign1, 3D_Component_File_Path=C:/Users/vemana/Desktop/alphabeta_HELIOS_Footprint.a3dcomp, dz=Wid_13, dy=Len_13, alpha=alpha13, beta=beta13)
  Reflector_Element3 [copper] = part_of(HFSSDesign1_3) in module13
  HFSSDesign1_4 = component(HFSSDesign1, 3D_Component_File_Path=C:/Users/vemana/Desktop/alphabeta_HELIOS_Footprint.a3dcomp, dz=Wid_14, dy=Len_14, alpha=alpha14, beta=beta14)
  Reflector_Element4 [copper] = part_of(HFSSDesign1_4) in module14
  HFSSDesign1_5 = component(HFSSDesign1, 3D_Component_File_Path=C:/Users/vemana/Desktop/alphabeta_HELIOS_Footprint.a3dcomp, dz=Wid_21, dy=Len_21, alpha=alpha21, beta=beta21)
  Reflector_Element5 [copper] = part_of(HFSSDesign1_5) in module21
  HFSSDesign1_6 = component(HFSSDesign1, 3D_Component_File_Path=C:/Users/vemana/Desktop/alphabeta_HELIOS_Footprint.a3dcomp, dz=Wid_22, dy=Len_22, alpha=alpha22, beta=beta22)
  Reflector_Element6 [copper] = part_of(HFSSDesign1_6) in module22
  HFSSDesign1_7 = component(HFSSDesign1, 3D_Component_File_Path=C:/Users/vemana/Desktop/alphabeta_HELIOS_Footprint.a3dcomp, dz=Wid_23, dy=Len_23, alpha=alpha23, beta=beta23)
  Reflector_Element7 [copper] = part_of(HFSSDesign1_7) in module23
  HFSSDesign1_8 = component(HFSSDesign1, 3D_Component_File_Path=C:/Users/vemana/Desktop/alphabeta_HELIOS_Footprint.a3dcomp, dz=Wid_24, dy=Len_24, alpha=alpha24, beta=beta24)
  Reflector_Element8 [copper] = part_of(HFSSDesign1_8) in module24
  HFSSDesign1_9 = component(HFSSDesign1, 3D_Component_File_Path=C:/Users/vemana/Desktop/alphabeta_HELIOS_Footprint.a3dcomp, dz=Wid_31, dy=Len_31, alpha=alpha31, beta=beta31)
  Reflector_Element9 [copper] = part_of(HFSSDesign1_9) in module31
  HFSSDesign1_10 = component(HFSSDesign1, 3D_Component_File_Path=C:/Users/vemana/Desktop/alphabeta_HELIOS_Footprint.a3dcomp, dz=Wid_32, dy=Len_32, alpha=alpha32, beta=beta32)
  Reflector_Element10 [copper] = part_of(HFSSDesign1_10) in module32
  HFSSDesign1_11 = component(HFSSDesign1, 3D_Component_File_Path=C:/Users/vemana/Desktop/alphabeta_HELIOS_Footprint.a3dcomp, dz=Wid_33, dy=Len_33, alpha=alpha33, beta=beta33)
  Reflector_Element11 [copper] = part_of(HFSSDesign1_11) in module33
  HFSSDesign1_12 = component(HFSSDesign1, 3D_Component_File_Path=C:/Users/vemana/Desktop/alphabeta_HELIOS_Footprint.a3dcomp, dz=Wid_34, dy=Len_34, alpha=alpha34, beta=beta34)
  Reflector_Element12 [copper] = part_of(HFSSDesign1_12) in module34
  HFSSDesign1_13 = component(HFSSDesign1, 3D_Component_File_Path=C:/Users/vemana/Desktop/alphabeta_HELIOS_Footprint.a3dcomp, dz=Wid_41, dy=Len_41, alpha=alpha41, beta=beta41)
  Reflector_Element13 [copper] = part_of(HFSSDesign1_13) in module41
  HFSSDesign1_14 = component(HFSSDesign1, 3D_Component_File_Path=C:/Users/vemana/Desktop/alphabeta_HELIOS_Footprint.a3dcomp, dz=Wid_42, dy=Len_42, alpha=alpha42, beta=beta42)
  Reflector_Element14 [copper] = part_of(HFSSDesign1_14) in module42
  HFSSDesign1_15 = component(HFSSDesign1, 3D_Component_File_Path=C:/Users/vemana/Desktop/alphabeta_HELIOS_Footprint.a3dcomp, dz=Wid_43, dy=Len_43, alpha=alpha43, beta=beta43)
  Reflector_Element15 [copper] = part_of(HFSSDesign1_15) in module43
  HFSSDesign1_16 = component(HFSSDesign1, 3D_Component_File_Path=C:/Users/vemana/Desktop/alphabeta_HELIOS_Footprint.a3dcomp, dz=Wid_44, dy=Len_44, alpha=alpha44, beta=beta44)
  Reflector_Element16 [copper] = part_of(HFSSDesign1_16) in module44
boundaries and excitations:
  HFSSDesign1_1_SBRRegion1: Hybrid Region Objects=Reflector_Element Type=SBR+
  HFSSDesign1_1_FiniteCond1: Finite Conductivity Objects=Reflector_Element UseMaterial Material=HFSSDesign1_1:copper IsInternal
  HFSSDesign1_2_SBRRegion1: Hybrid Region Objects=Reflector_Element2 Type=SBR+
  HFSSDesign1_2_FiniteCond1: Finite Conductivity Objects=Reflector_Element2 UseMaterial Material=HFSSDesign1_2:copper IsInternal
  HFSSDesign1_3_SBRRegion1: Hybrid Region Objects=Reflector_Element3 Type=SBR+
  HFSSDesign1_3_FiniteCond1: Finite Conductivity Objects=Reflector_Element3 UseMaterial Material=HFSSDesign1_3:copper IsInternal
  HFSSDesign1_4_SBRRegion1: Hybrid Region Objects=Reflector_Element4 Type=SBR+
  HFSSDesign1_4_FiniteCond1: Finite Conductivity Objects=Reflector_Element4 UseMaterial Material=HFSSDesign1_4:copper IsInternal
  HFSSDesign1_5_SBRRegion1: Hybrid Region Objects=Reflector_Element5 Type=SBR+
  HFSSDesign1_5_FiniteCond1: Finite Conductivity Objects=Reflector_Element5 UseMaterial Material=HFSSDesign1_5:copper IsInternal
  HFSSDesign1_6_SBRRegion1: Hybrid Region Objects=Reflector_Element6 Type=SBR+
  HFSSDesign1_6_FiniteCond1: Finite Conductivity Objects=Reflector_Element6 UseMaterial Material=HFSSDesign1_6:copper IsInternal
  HFSSDesign1_7_SBRRegion1: Hybrid Region Objects=Reflector_Element7 Type=SBR+
  HFSSDesign1_7_FiniteCond1: Finite Conductivity Objects=Reflector_Element7 UseMaterial Material=HFSSDesign1_7:copper IsInternal
  HFSSDesign1_8_SBRRegion1: Hybrid Region Objects=Reflector_Element8 Type=SBR+
  HFSSDesign1_8_FiniteCond1: Finite Conductivity Objects=Reflector_Element8 UseMaterial Material=HFSSDesign1_8:copper IsInternal
  HFSSDesign1_9_SBRRegion1: Hybrid Region Objects=Reflector_Element9 Type=SBR+
  HFSSDesign1_9_FiniteCond1: Finite Conductivity Objects=Reflector_Element9 UseMaterial Material=HFSSDesign1_9:copper IsInternal
  HFSSDesign1_10_SBRRegion1: Hybrid Region Objects=Reflector_Element10 Type=SBR+
  HFSSDesign1_10_FiniteCond1: Finite Conductivity Objects=Reflector_Element10 UseMaterial Material=HFSSDesign1_10:copper IsInternal
  HFSSDesign1_11_SBRRegion1: Hybrid Region Objects=Reflector_Element11 Type=SBR+
  HFSSDesign1_11_FiniteCond1: Finite Conductivity Objects=Reflector_Element11 UseMaterial Material=HFSSDesign1_11:copper IsInternal
  HFSSDesign1_12_SBRRegion1: Hybrid Region Objects=Reflector_Element12 Type=SBR+
  HFSSDesign1_12_FiniteCond1: Finite Conductivity Objects=Reflector_Element12 UseMaterial Material=HFSSDesign1_12:copper IsInternal
  HFSSDesign1_13_SBRRegion1: Hybrid Region Objects=Reflector_Element13 Type=SBR+
  HFSSDesign1_13_FiniteCond1: Finite Conductivity Objects=Reflector_Element13 UseMaterial Material=HFSSDesign1_13:copper IsInternal
  HFSSDesign1_14_SBRRegion1: Hybrid Region Objects=Reflector_Element14 Type=SBR+
  HFSSDesign1_14_FiniteCond1: Finite Conductivity Objects=Reflector_Element14 UseMaterial Material=HFSSDesign1_14:copper IsInternal
  HFSSDesign1_15_SBRRegion1: Hybrid Region Objects=Reflector_Element15 Type=SBR+
  HFSSDesign1_15_FiniteCond1: Finite Conductivity Objects=Reflector_Element15 UseMaterial Material=HFSSDesign1_15:copper IsInternal
  HFSSDesign1_16_SBRRegion1: Hybrid Region Objects=Reflector_Element16 Type=SBR+
  HFSSDesign1_16_FiniteCond1: Finite Conductivity Objects=Reflector_Element16 UseMaterial Material=HFSSDesign1_16:copper IsInternal
  IncPWave1: Plane Incident Wave PhiStart="(180+az_angle*180/pi) deg" PhiStop="(180+az_angle*180/pi) deg" PhiPoints=1 ThetaStart="-el_angle*180/pi deg" ThetaStop="-el_angle*180/pi deg" ThetaPoints=1 EoPhi=1 EoTheta=0 OriginX=spacing_x OriginY=spacing_y OriginZ=spacing_z IsPropagating
setups:
  Setup1: HfssDriven RayDensityPerWavelength=4 MaxNumberOfBounces=5 RadiationSetup=56 PTDUTDSimulationSettings="PTD Correction + UTD Rays" PTDEdgeDensity=20 ComputeFarFields
    sweep Sweep: point 28GHz;
source amplitudes:
  IncPWave1:1: 1 0deg
radiation setups:
  FarField_Setup: Infinite Sphere Theta=0deg..180deg step 1deg Phi=-90deg..90deg step 1deg CoordSystem=central_RIS_Orientation
reports:
  FarField_Report: dB(RCSTotal) vs Phi, Theta on Setup1 : Sweep, FarField_Setup [Freq=28GHz IWavePhi=180deg IWaveTheta=-90deg]
