# Ansys Electronics Desktop project, version 2021.2
materials:
  vacuum: permittivity=1
  pec: conductivity=1e+30

design HFSSDesign1 (HFSS, SBR+, model units mm)
variables:
  alpha11 = 2deg
  beta11 = 2deg
  Len_11 = Length
  Wid_11 = Width
  spacing_magnitude = 1meter
  el_angle = 95deg
  az_angle = 0deg
  spacing_x = spacing_magnitude*sin(el_angle*pi/180 deg)*cos(az_angle*pi/180 deg)
  spacing_y = spacing_magnitude*sin(el_angle*pi/180 deg)*sin(-1*az_angle*pi/180 deg)
  spacing_z = spacing_magnitude*cos(el_angle*pi/180 deg)
  Length = 10cm
  Width = 10cm
  alpha12 = alpha11
  beta12 = beta11
  Len_12 = Len_11
  Wid_12 = Wid_11
  alpha21 = alpha11
  beta21 = beta11
  Len_21 = Len_11
  Wid_21 = Wid_11
  alpha22 = alpha12
  beta22 = beta12
  Len_22 = Len_12
  Wid_22 = Wid_12
  Len_13 = Len_12
  alpha13 = alpha12
  beta13 = beta12
  Wid_13 = Wid_12
  alpha23 = alpha13
  beta23 = beta13
  Len_23 = Len_13
  Wid_23 = Wid_13
  alpha31 = alpha21
  beta31 = beta21
  Len_31 = Len_21
  Wid_31 = Wid_21
  alpha32 = alpha22
  beta32 = beta22
  Len_32 = Len_22
  Wid_32 = WId_22
  alpha33 = alpha23
  beta33 = beta23
  Len_33 = Len_23
  Wid_33 = Wid_23
  beta14 = beta13
  Len_14 = Len_13
  Wid_14 = Wid_13
  alpha14 = alpha13
  alpha24 = alpha14
  beta24 = beta14
  Len_24 = Len_14
  Wid_24 = Wid_14
  alpha34 = alpha24
  beta34 = beta24
  Len_34 = Len_24
  Wid_34 = Wid_24
  alpha41 = alpha31
  beta41 = beta31
  Len_41 = Len_31
  Wid_41 = Wid_31
  alpha42 = alpha32
  beta42 = beta32
  Len_42 = Len_32
  Wid_42 = Wid_32
  alpha43 = alpha33
  beta43 = beta33
  Len_43 = Len_33
  Wid_43 = Wid_33
  alpha44 = alpha34
  beta44 = beta34
  Len_44 = Len_34
  Wid_44 = Wid_34
  Len_15 = Len_14
  beta15 = beta14
  alpha15 = alpha14
  Wid_15 = Wid_14
  alpha25 = alpha15
  beta25 = beta15
  Len_25 = Len_15
  Wid_25 = Wid_15
  alpha35 = alpha25
  beta35 = beta25
  Len_35 = Len_25
  Wid_35 = Wid_25
  alpha45 = alpha35
  beta45 = beta35
  Len_45 = Len_35
  Wid_45 = Wid_35
  alpha55 = alpha45
  beta55 = beta45
  Len_55 = Len_45
  Wid_55 = Wid_45
  alpha54 = alpha44
  beta54 = beta44
  Len_54 = Len_44
  Wid_54 = Wid_44
  alpha53 = alpha43
  beta53 = beta43
  Len_53 = Len_43
  Wid_53 = Wid_43
  alpha52 = alpha42
  beta52 = beta42
  Len_52 = Len_42
  Wid_52 = Wid_42
  alpha51 = alpha41
  beta51 = beta41
  Len_51 = Len_41
  Wid_51 = Wid_41
  Len_16 = Len_15
  beta16 = beta15
  Wid_16 = Wid_15
  alpha16 = alpha15
  alpha26 = alpha16
  beta26 = beta16
  Len_26 = Len_16
  Wid_26 = Wid_16
  alpha36 = alpha26
  beta36 = beta26
  Len_36 = Len_26
  Wid_36 = WId_26
  alpha46 = alpha36
  beta46 = beta36
  Len_46 = Len_36
  Wid_46 = Wid_36
  alpha56 = alpha46
  beta56 = beta46
  Len_56 = Len_46
  Wid_56 = Wid_46
  alpha66 = alpha56
  beta66 = beta56
  Len_66 = Len_56
  Wid_66 = Wid_56
  alpha65 = alpha55
  beta65 = beta55
  Len_65 = Len_55
  Wid_65 = Wid_55
  alpha64 = alpha54
  beta64 = beta54
  Len_64 = Len_54
  Wid_64 = Wid_54
  alpha63 = alpha53
  beta63 = beta53
  Len_63 = Len_53
  Wid_63 = Wid_53
  alpha62 = alpha52
  beta62 = beta52
  Len_62 = Len_52
  Wid_62 = Wid_52
  alpha61 = alpha51
  beta61 = beta51
  Len_61 = Len_51
  Wid_61 = Wid_51
  Wid_17 = Wid_16
  beta17 = beta16
  alpha17 = alpha16
  Len_17 = Len_16
  alpha27 = alpha17
  beta27 = beta17
  Len_27 = Len_17
  Wid_27 = Wid_17
  alpha37 = alpha27
  beta37 = beta27
  Len_37 = Len_27
  Wid_37 = Wid_27
  alpha47 = alpha37
  beta47 = beta37
  Len_47 = Len_37
  Wid_47 = Wid_37
  alpha57 = alpha47
  beta57 = beta47
  Len_57 = Len_47
  Wid_57 = Wid_47
  alpha67 = alpha57
  beta67 = beta57
  Len_67 = Len_57
  Wid_67 = Wid_57
  alpha77 = alpha67
  beta77 = beta67
  Len_77 = Len_67
  Wid_77 = Wid_67
  alpha76 = alpha66
  beta76 = beta66
  Len_76 = Len_66
  Wid_76 = Wid_66
  alpha75 = alpha65
  beta75 = beta65
  Len_75 = Len_65
  Wid_75 = Wid_65
  alpha74 = alpha64
  beta74 = beta64
  Len_74 = Len_64
  Wid_74 = Wid_64
  alpha73 = alpha63
  beta73 = beta63
  Len_73 = Len_63
  Wid_73 = Wid_63
  alpha72 = alpha62
  beta72 = beta62
  Len_72 = Len_62
  Wid_72 = Wid_62
  alpha71 = alpha61
  beta71 = beta61
  Len_71 = Len_61
  Wid_71 = Wid_61
  alpha18 = alpha17
  beta18 = beta17
  Len_18 = Len_17
  Wid_18 = Wid_17
  alpha28 = alpha18
  beta28 = beta18
  Len_28 = Len_18
  Wid_28 = Wid_18
  alpha38 = alpha28
  beta38 = beta28
  Len_38 = Len_28
  Wid_38 = Wid_28
  alpha48 = alpha38
  beta48 = beta38
  Len_48 = Len_38
  Wid_48 = Wid_38
  alpha58 = alpha48
  beta58 = beta48
  Len_58 = Len_48
  Wid_58 = Wid_48
  alpha68 = alpha58
  beta68 = beta58
  Len_68 = Len_58
  Wid_68 = Wid_58
  alpha78 = alpha68
  beta78 = beta68
  Len_78 = Len_68
  Wid_78 = Wid_68
  alpha81 = alpha71
  beta81 = beta71
  Len_81 = Len_71
  Wid_81 = Wid_71
  alpha82 = alpha72
  beta82 = beta72
  Len_82 = Len_72
  Wid_82 = Wid_72
  alpha83 = alpha73
  beta83 = beta73
  Len_83 = Len_73
  Wid_83 = Wid_73
  alpha84 = alpha74
  beta84 = beta74
  Len_84 = Len_74
  Wid_84 = Wid_74
  alpha85 = alpha75
  beta85 = beta75
  Len_85 = Len_75
  Wid_85 = Wid_75
  alpha86 = alpha76
  beta86 = beta76
  Len_86 = Len_76
  Wid_86 = Wid_76
  alpha87 = alpha77
  beta87 = beta77
  Len_87 = Len_77
  Wid_87 = Wid_77
  alpha88 = alpha78
  beta88 = beta78
  Len_88 = Len_78
  Wid_88 = Wid_78
geometry:
  coordinate_system module11 = origin=(0mm, 0mm, 0mm) x=(1mm, 0mm, 0mm) y=(0mm, 1mm, 0mm)
  coordinate_system module12 = origin=(0mm, Length, 0mm) x=(1mm, 0mm, 0mm) y=(0mm, 1mm, 0mm)
  coordinate_system module21 = origin=(0mm, 0mm, Width) x=(1mm, 0mm, 0mm) y=(0mm, 1mm, 0mm)
  coordinate_system module22 = origin=(0mm, Length, Width) x=(1mm, 0mm, 0mm) y=(0mm, 1mm, 0mm)
  coordinate_system module13 = origin=(0mm, 2*Length, 0mm) x=(1mm, 0mm, 0mm) y=(0mm, 1mm, 0mm)
  coordinate_system module23 = origin=(0mm, 2*Length, Width) x=(1mm, 0mm, 0mm) y=(0mm, 1mm, 0mm)
  coordinate_system module31 = origin=(0mm, 0mm, 2*Width) x=(1mm, 0mm, 0mm) y=(0mm, 1mm, 0mm)
  coordinate_system module32 = origin=(0mm, Length, 2*Width) x=(1mm, 0mm, 0mm) y=(0mm, 1mm, 0mm)
  coordinate_system module33 = origin=(0mm, 2*Length, 2*Width) x=(1mm, 0mm, 0mm) y=(0mm, 1mm, 0mm)
  coordinate_system module14 = origin=(0mm, 3*Length, 0mm) x=(1mm, 0mm, 0mm) y=(0mm, 1mm, 0mm)
  coordinate_system module24 = origin=(0mm, 3*Length, Width) x=(1mm, 0mm, 0mm) y=(0mm, 1mm, 0mm)
  coordinate_system module34 = origin=(0mm, 3*Length, 2*Width) x=(1mm, 0mm, 0mm) y=(0mm, 1mm, 0mm)
  coordinate_system module41 = origin=(0mm, 0mm, 3*Width) x=(1mm, 0mm, 0mm) y=(0mm, 1mm, 0mm)
  coordinate_system module42 = origin=(0mm, Length, 3*Width) x=(1mm, 0mm, 0mm) y=(0mm, 1mm, 0mm)
  coordinate_system module43 = origin=(0mm, 2*Length, 3*Width) x=(1mm, 0mm, 0mm) y=(0mm, 1mm, 0mm)
  coordinate_system module44 = origin=(0mm, 3*Length, 3*Width) x=(1mm, 0mm, 0mm) y=(0mm, 1mm, 0mm)
  coordinate_system module15 = origin=(0mm, 4*Length, 0mm) x=(1mm, 0mm, 0mm) y=(0mm, 1mm, 0mm)
  coordinate_system module25 = origin=(0mm, 4*Length, Width) x=(1mm, 0mm, 0mm) y=(0mm, 1mm, 0mm)
  coordinate_system module35 = origin=(0mm, 4*Length, 2*Width) x=(1mm, 0mm, 0mm) y=(0mm, 1mm, 0mm)
  coordinate_system module45 = origin=(0mm, 4*Length, 3*Width) x=(1mm, 0mm, 0mm) y=(0mm, 1mm, 0mm)
  coordinate_system module55 = origin=(0mm, 4*Length, 4*Width) x=(1mm, 0mm, 0mm) y=(0mm, 1mm, 0mm)
  coordinate_system module54 = origin=(0mm, 3*Length, 4*Width) x=(1mm, 0mm, 0mm) y=(0mm, 1mm, 0mm)
  coordinate_system module53 = origin=(0mm, 2*Length, 4*Width) x=(1mm, 0mm, 0mm) y=(0mm, 1mm, 0mm)
  coordinate_system module52 = origin=(0mm, 1*Length, 4*Width) x=(1mm, 0mm, 0mm) y=(0mm, 1mm, 0mm)
  coordinate_system module51 = origin=(0mm, 0*Length, 4*Width) x=(1mm, 0mm, 0mm) y=(0mm, 1mm, 0mm)
  coordinate_system module16 = origin=(0mm, 5*Length, 0mm) x=(1mm, 0mm, 0mm) y=(0mm, 1mm, 0mm)
  coordinate_system module26 = origin=(0mm, 5*Length, Width) x=(1mm, 0mm, 0mm) y=(0mm, 1mm, 0mm)
  coordinate_system module36 = origin=(0mm, 5*Length, 2*Width) x=(1mm, 0mm, 0mm) y=(0mm, 1mm, 0mm)
  coordinate_system module46 = origin=(0mm, 5*Length, 3*Width) x=(1mm, 0mm, 0mm) y=(0mm, 1mm, 0mm)
  coordinate_system module56 = origin=(0mm, 5*Length, 4*Width) x=(1mm, 0mm, 0mm) y=(0mm, 1mm, 0mm)
  coordinate_system module66 = origin=(0mm, 5*Length, 5*Width) x=(1mm, 0mm, 0mm) y=(0mm, 1mm, 0mm)
  coordinate_system module65 = origin=(0mm, 4*Length, 5*Width) x=(1mm, 0mm, 0mm) y=(0mm, 1mm, 0mm)
  coordinate_system module64 = origin=(0mm, 3*Length, 5*Width) x=(1mm, 0mm, 0mm) y=(0mm, 1mm, 0mm)
  coordinate_system module63 = origin=(0mm, 2*Length, 5*Width) x=(1mm, 0mm, 0mm) y=(0mm, 1mm, 0mm)
  coordinate_system module62 = origin=(0mm, 1*Length, 5*Width) x=(1mm, 0mm, 0mm) y=(0mm, 1mm, 0mm)
  coordinate_system module61 = origin=(0mm, 0*Length, 5*Width) x=(1mm, 0mm, 0mm) y=(0mm, 1mm, 0mm)
  coordinate_system module17 = origin=(0mm, 6*Length, 0mm) x=(1mm, 0mm, 0mm) y=(0mm, 1mm, 0mm)
  coordinate_system module27 = origin=(0mm, 6 *Length, Width) x=(1mm, 0mm, 0mm) y=(0mm, 1mm, 0mm)
  coordinate_system module37 = origin=(0mm, 6*Length, 2*Width) x=(1mm, 0mm, 0mm) y=(0mm, 1mm, 0mm)
  coordinate_system module47 = origin=(0mm, 6*Length, 3*Width) x=(1mm, 0mm, 0mm) y=(0mm, 1mm, 0mm)
  coordinate_system module57 = origin=(0mm, 6*Length, 4*Width) x=(1mm, 0mm, 0mm) y=(0mm, 1mm, 0mm)
  coordinate_system module67 = origin=(0mm, 6*Length, 5*Width) x=(1mm, 0mm, 0mm) y=(0mm, 1mm, 0mm)
  coordinate_system module77 = origin=(0mm, 6*Length, 6*Width) x=(1mm, 0mm, 0mm) y=(0mm, 1mm, 0mm)
  coordinate_system module76 = origin=(0mm, 5*Length, 6*Width) x=(1mm, 0mm, 0mm) y=(0mm, 1mm, 0mm)
  coordinate_system module75 = origin=(0mm, 4*Length, 6*Width) x=(1mm, 0mm, 0mm) y=(0mm, 1mm, 0mm)
  coordinate_system module74 = origin=(0mm, 3*Length, 6*Width) x=(1mm, 0mm, 0mm) y=(0mm, 1mm, 0mm)
  coordinate_system module73 = origin=(0mm, 2*Length, 6*Width) x=(1mm, 0mm, 0mm) y=(0mm, 1mm, 0mm)
  coordinate_system module72 = origin=(0mm, 1*Length, 6*Width) x=(1mm, 0mm, 0mm) y=(0mm, 1mm, 0mm)
  coordinate_system module71 = origin=(0mm, 0*Length, 6*Width) x=(1mm, 0mm, 0mm) y=(0mm, 1mm, 0mm)
  coordinate_system module18 = origin=(0mm, 7*Length, 0mm) x=(1mm, 0mm, 0mm) y=(0mm, 1mm, 0mm)
  coordinate_system module28 = origin=(0mm, 7 *Length, Width) x=(1mm, 0mm, 0mm) y=(0mm, 1mm, 0mm)
  coordinate_system module38 = origin=(0mm, 7*Length, 2*Width) x=(1mm, 0mm, 0mm) y=(0mm, 1mm, 0mm)
  coordinate_system module48 = origin=(0mm, 7*Length, 3*Width) x=(1mm, 0mm, 0mm) y=(0mm, 1mm, 0mm)
  coordinate_system module58 = origin=(0mm, 7*Length, 4*Width) x=(1mm, 0mm, 0mm) y=(0mm, 1mm, 0mm)
  coordinate_system module68 = origin=(0mm, 7*Length, 5*Width) x=(1mm, 0mm, 0mm) y=(0mm, 1mm, 0mm)
  coordinate_system module78 = origin=(0mm, 7*Length, 6*Width) x=(1mm, 0mm, 0mm) y=(0mm, 1mm, 0mm)
  coordinate_system module81 = origin=(0mm, 0*Length, 7*Width) x=(1mm, 0mm, 0mm) y=(0mm, 1mm, 0mm)
  coordinate_system module82 = origin=(0mm, 1*Length, 7*Width) x=(1mm, 0mm, 0mm) y=(0mm, 1mm, 0mm)
  coordinate_system module83 = origin=(0mm, 2*Length, 7*Width) x=(1mm, 0mm, 0mm) y=(0mm, 1mm, 0mm)
  coordinate_system module84 = origin=(0mm, 3*Length, 7*Width) x=(1mm, 0mm, 0mm) y=(0mm, 1mm, 0mm)
  coordinate_system module85 = origin=(0mm, 4*Length, 7*Width) x=(1mm, 0mm, 0mm) y=(0mm, 1mm, 0mm)
  coordinate_system module86 = origin=(0mm, 5*Length, 7*Width) x=(1mm, 0mm, 0mm) y=(0mm, 1mm, 0mm)
  coordinate_system module87 = origin=(0mm, 6*Length, 7*Width) x=(1mm, 0mm, 0mm) y=(0mm, 1mm, 0mm)
  coordinate_system module88 = origin=(0mm, 7*Length, 7*Width) x=(1mm, 0mm, 0mm) y=(0mm, 1mm, 0mm)
  HFSSDesign1_1 = component(HFSSDesign1, 3D_Component_File_Path=C:/Users/vemana/Desktop/alphabeta_HELIOS_Footprint.a3dcomp, dy=Len_11, dz=Wid_11, beta=beta11, alpha=alpha11)
  Reflector_Element [copper] = part_of(HFSSDesign1_1) in module11
  HFSSDesign1_2 = component(HFSSDesign1, 3D_Component_File_Path=C:/Users/vemana/Desktop/alphabeta_HELIOS_Footprint.a3dcomp, dy=Len_12, dz=Wid_12, beta=beta12, alpha=alpha12)
  Reflector_Element2 [copper] = part_of(HFSSDesign1_2) in module12
  HFSSDesign1_3 = component(HFSSDesign1, 3D_Component_File_Path=C:/Users/vemana/Desktop/alphabeta_HELIOS_Footprint.a3dcomp, dy=Len_13, dz=Wid_13, beta=beta13, alpha=alpha13)
  Reflector_Element3 [copper] = part_of(HFSSDesign1_3) in module13
  HFSSDesign1_4 = component(HFSSDesign1, 3D_Component_File_Path=C:/Users/vemana/Desktop/alphabeta_HELIOS_Footprint.a3dcomp, dy=Len_14, dz=Wid_14, beta=beta14, alpha=alpha14)
  Reflector_Element4 [copper] = part_of(HFSSDesign1_4) in module14
  HFSSDesign1_5 = component(HFSSDesign1, 3D_Component_File_Path=C:/Users/vemana/Desktop/alphabeta_HELIOS_Footprint.a3dcomp, dy=Len_15, dz=Wid_15, beta=beta15, alpha=alpha15)
  Reflector_Element5 [copper] = part_of(HFSSDesign1_5) in module15
  HFSSDesign1_6 = component(HFSSDesign1, 3D_Component_File_Path=C:/Users/vemana/Desktop/alphabeta_HELIOS_Footprint.a3dcomp, dy=Len_16, dz=Wid_16, beta=beta16, alpha=alpha16)
  Reflector_Element6 [copper] = part_of(HFSSDesign1_6) in module16
  HFSSDesign1_7 = component(HFSSDesign1, 3D_Component_File_Path=C:/Users/vemana/Desktop/alphabeta_HELIOS_Footprint.a3dcomp, dy=Len_17, dz=Wid_17, beta=beta17, alpha=alpha17)
  Reflector_Element7 [copper] = part_of(HFSSDesign1_7) in module17
  HFSSDesign1_8 = component(HFSSDesign1, 3D_Component_File_Path=C:/Users/vemana/Desktop/alphabeta_HELIOS_Footprint.a3dcomp, dy=Len_18, dz=Wid_18, beta=beta18, alpha=alpha18)
  Reflector_Element8 [copper] = part_of(HFSSDesign1_8) in module18
  HFSSDesign1_9 = component(HFSSDesign1, 3D_Component_File_Path=C:/Users/vemana/Desktop/alphabeta_HELIOS_Footprint.a3dcomp, dy=Len_21, dz=Wid_21, beta=beta21, alpha=alpha21)
  Reflector_Element9 [copper] = part_of(HFSSDesign1_9) in module21
  HFSSDesign1_10 = component(HFSSDesign1, 3D_Component_File_Path=C:/Users/vemana/Desktop/alphabeta_HELIOS_Footprint.a3dcomp, dy=Len_22, dz=Wid_22, beta=beta22, alpha=alpha22)
  Reflector_Element10 [copper] = part_of(HFSSDesign1_10) in module22
  HFSSDesign1_11 = component(HFSSDesign1, 3D_Component_File_Path=C:/Users/vemana/Desktop/alphabeta_HELIOS_Footprint.a3dcomp, dy=Len_23, dz=Wid_23, beta=beta23, alpha=alpha23)
  Reflector_Element11 [copper] = part_of(HFSSDesign1_11) in module23
  HFSSDesign1_12 = component(HFSSDesign1, 3D_Component_File_Path=C:/Users/vemana/Desktop/alphabeta_HELIOS_Footprint.a3dcomp, dy=Len_24, dz=Wid_24, beta=beta24, alpha=alpha24)
  Reflector_Element12 [copper] = part_of(HFSSDesign1_12) in module24
  HFSSDesign1_13 = component(HFSSDesign1, 3D_Component_File_Path=C:/Users/vemana/Desktop/alphabeta_HELIOS_Footprint.a3dcomp, dy=Len_25, dz=Wid_25, beta=beta25, alpha=alpha25)
  Reflector_Element13 [copper] = part_of(HFSSDesign1_13) in module25
  HFSSDesign1_14 = component(HFSSDesign1, 3D_Component_File_Path=C:/Users/vemana/Desktop/alphabeta_HELIOS_Footprint.a3dcomp, dy=Len_26, dz=Wid_26, beta=beta26, alpha=alpha26)
  Reflector_Element14 [copper] = part_of(HFSSDesign1_14) in module26
  HFSSDesign1_15 = component(HFSSDesign1, 3D_Component_File_Path=C:/Users/vemana/Desktop/alphabeta_HELIOS_Footprint.a3dcomp, dy=Len_27, dz=Wid_27, beta=beta27, alpha=alpha27)
  Reflector_Element15 [copper] = part_of(HFSSDesign1_15) in module27
  HFSSDesign1_16 = component(HFSSDesign1, 3D_Component_File_Path=C:/Users/vemana/Desktop/alphabeta_HELIOS_Footprint.a3dcomp, dy=Len_28, dz=Wid_28, beta=beta28, alpha=alpha28)
  Reflector_Element16 [copper] = part_of(HFSSDesign1_16) in module28
  HFSSDesign1_17 = component(HFSSDesign1, 3D_Component_File_Path=C:/Users/vemana/Desktop/alphabeta_HELIOS_Footprint.a3dcomp, dy=Len_31, dz=Wid_31, beta=beta31, alpha=alpha31)
  Reflector_Element17 [copper] = part_of(HFSSDesign1_17) in module31
  HFSSDesign1_18 = component(HFSSDesign1, 3D_Component_File_Path=C:/Users/vemana/Desktop/alphabeta_HELIOS_Footprint.a3dcomp, dy=Len_32, dz=Wid_32, beta=beta32, alpha=alpha32)
  Reflector_Element18 [copper] = part_of(HFSSDesign1_18) in module32
  HFSSDesign1_19 = component(HFSSDesign1, 3D_Component_File_Path=C:/Users/vemana/Desktop/alphabeta_HELIOS_Footprint.a3dcomp, dy=Len_33, dz=Wid_33, beta=beta33, alpha=alpha33)
  Reflector_Element19 [copper] = part_of(HFSSDesign1_19) in module33
  HFSSDesign1_20 = component(HFSSDesign1, 3D_Component_File_Path=C:/Users/vemana/Desktop/alphabeta_HELIOS_Footprint.a3dcomp, dy=Len_34, dz=Wid_34, beta=beta34, alpha=alpha34)
  Reflector_Element20 [copper] = part_of(HFSSDesign1_20) in module34
  HFSSDesign1_21 = component(HFSSDesign1, 3D_Component_File_Path=C:/Users/vemana/Desktop/alphabeta_HELIOS_Footprint.a3dcomp, dy=Len_35, dz=Wid_35, beta=beta35, alpha=alpha35)
  Reflector_Element21 [copper] = part_of(HFSSDesign1_21) in module35
  HFSSDesign1_22 = component(HFSSDesign1, 3D_Component_File_Path=C:/Users/vemana/Desktop/alphabeta_HELIOS_Footprint.a3dcomp, dy=Len_36, dz=Wid_36, beta=beta36, alpha=alpha36)
  Reflector_Element22 [copper] = part_of(HFSSDesign1_22) in module36
  HFSSDesign1_23 = component(HFSSDesign1, 3D_Component_File_Path=C:/Users/vemana/Desktop/alphabeta_HELIOS_Footprint.a3dcomp, dy=Len_37, dz=Wid_37, beta=beta37, alpha=alpha37)
  Reflector_Element23 [copper] = part_of(HFSSDesign1_23) in module37
  HFSSDesign1_24 = component(HFSSDesign1, 3D_Component_File_Path=C:/Users/vemana/Desktop/alphabeta_HELIOS_Footprint.a3dcomp, dy=Len_38, dz=Wid_38, beta=beta38, alpha=alpha38)
  Reflector_Element24 [copper] = part_of(HFSSDesign1_24) in module38
  HFSSDesign1_25 = component(HFSSDesign1, 3D_Component_File_Path=C:/Users/vemana/Desktop/alphabeta_HELIOS_Footprint.a3dcomp, dy=Len_41, dz=Wid_41, beta=beta41, alpha=alpha41)
  Reflector_Element25 [copper] = part_of(HFSSDesign1_25) in module41
  HFSSDesign1_26 = component(HFSSDesign1, 3D_Component_File_Path=C:/Users/vemana/Desktop/alphabeta_HELIOS_Footprint.a3dcomp, dy=Len_42, dz=Wid_42, beta=beta42, alpha=alpha42)
  Reflector_Element26 [copper] = part_of(HFSSDesign1_26) in module42
  HFSSDesign1_27 = component(HFSSDesign1, 3D_Component_File_Path=C:/Users/vemana/Desktop/alphabeta_HELIOS_Footprint.a3dcomp, dy=Len_43, dz=Wid_43, beta=beta43, alpha=alpha43)
  Reflector_Element27 [copper] = part_of(HFSSDesign1_27) in module43
  HFSSDesign1_28 = component(HFSSDesign1, 3D_Component_File_Path=C:/Users/vemana/Desktop/alphabeta_HELIOS_Footprint.a3dcomp, dy=Len_44, dz=Wid_44, beta=beta44, alpha=alpha44)
  Reflector_Element28 [copper] = part_of(HFSSDesign1_28) in module44
  HFSSDesign1_29 = component(HFSSDesign1, 3D_Component_File_Path=C:/Users/vemana/Desktop/alphabeta_HELIOS_Footprint.a3dcomp, dy=Len_45, dz=Wid_45, beta=beta45, alpha=alpha45)
  Reflector_Element29 [copper] = part_of(HFSSDesign1_29) in module45
  HFSSDesign1_30 = component(HFSSDesign1, 3D_Component_File_Path=C:/Users/vemana/Desktop/alphabeta_HELIOS_Footprint.a3dcomp, dy=Len_46, dz=Wid_46, beta=beta46, alpha=alpha46)
  Reflector_Element30 [copper] = part_of(HFSSDesign1_30) in module46
  HFSSDesign1_31 = component(HFSSDesign1, 3D_Component_File_Path=C:/Users/vemana/Desktop/alphabeta_HELIOS_Footprint.a3dcomp, dy=Len_47, dz=Wid_47, beta=beta47, alpha=alpha47)
  Reflector_Element31 [copper] = part_of(HFSSDesign1_31) in module47
  HFSSDesign1_32 = component(HFSSDesign1, 3D_Component_File_Path=C:/Users/vemana/Desktop/alphabeta_HELIOS_Footprint.a3dcomp, dy=Len_48, dz=Wid_48, beta=beta48, alpha=alpha48)
  Reflector_Element32 [copper] = part_of(HFSSDesign1_32) in module48
  HFSSDesign1_33 = component(HFSSDesign1, 3D_Component_File_Path=C:/Users/vemana/Desktop/alphabeta_HELIOS_Footprint.a3dcomp, dy=Len_51, dz=Wid_51, beta=beta51, alpha=alpha51)
  Reflector_Element33 [copper] = part_of(HFSSDesign1_33) in module51
  HFSSDesign1_34 = component(HFSSDesign1, 3D_Component_File_Path=C:/Users/vemana/Desktop/alphabeta_HELIOS_Footprint.a3dcomp, dy=Len_52, dz=Wid_52, beta=beta52, alpha=alpha52)
  Reflector_Element34 [copper] = part_of(HFSSDesign1_34) in module52
  HFSSDesign1_35 = component(HFSSDesign1, 3D_Component_File_Path=C:/Users/vemana/Desktop/alphabeta_HELIOS_Footprint.a3dcomp, dy=Len_53, dz=Wid_53, beta=beta53, alpha=alpha53)
  Reflector_Element35 [copper] = part_of(HFSSDesign1_35) in module53
  HFSSDesign1_36 = component(HFSSDesign1, 3D_Component_File_Path=C:/Users/vemana/Desktop/alphabeta_HELIOS_Footprint.a3dcomp, dy=Len_54, dz=Wid_54, beta=beta54, alpha=alpha54)
  Reflector_Element36 [copper] = part_of(HFSSDesign1_36) in module54
  HFSSDesign1_37 = component(HFSSDesign1, 3D_Component_File_Path=C:/Users/vemana/Desktop/alphabeta_HELIOS_Footprint.a3dcomp, dy=Len_55, dz=Wid_55, beta=beta55, alpha=alpha55)
  Reflector_Element37 [copper] = part_of(HFSSDesign1_37) in module55
  HFSSDesign1_38 = component(HFSSDesign1, 3D_Component_File_Path=C:/Users/vemana/Desktop/alphabeta_HELIOS_Footprint.a3dcomp, dy=Len_56, dz=Wid_56, beta=beta56, alpha=alpha56)
  Reflector_Element38 [copper] = part_of(HFSSDesign1_38) in module56
  HFSSDesign1_39 = component(HFSSDesign1, 3D_Component_File_Path=C:/Users/vemana/Desktop/alphabeta_HELIOS_Footprint.a3dcomp, dy=Len_57, dz=Wid_57, beta=beta57, alpha=alpha57)
  Reflector_Element39 [copper] = part_of(HFSSDesign1_39) in module57
  HFSSDesign1_40 = component(HFSSDesign1, 3D_Component_File_Path=C:/Users/vemana/Desktop/alphabeta_HELIOS_Footprint.a3dcomp, dy=Len_58, dz=Wid_58, beta=beta58, alpha=alpha58)
  Reflector_Element40 [copper] = part_of(HFSSDesign1_40) in module58
  HFSSDesign1_41 = component(HFSSDesign1, 3D_Component_File_Path=C:/Users/vemana/Desktop/alphabeta_HELIOS_Footprint.a3dcomp, dy=Len_61, dz=Wid_61, beta=beta61, alpha=alpha61)
  Reflector_Element41 [copper] = part_of(HFSSDesign1_41) in module61
  HFSSDesign1_42 = component(HFSSDesign1, 3D_Component_File_Path=C:/Users/vemana/Desktop/alphabeta_HELIOS_Footprint.a3dcomp, dy=Len_62, dz=Wid_62, beta=beta62, alpha=alpha62)
  Reflector_Element42 [copper] = part_of(HFSSDesign1_42) in module62
  HFSSDesign1_43 = component(HFSSDesign1, 3D_Component_File_Path=C:/Users/vemana/Desktop/alphabeta_HELIOS_Footprint.a3dcomp, dy=Len_63, dz=Wid_63, beta=beta63, alpha=alpha63)
  Reflector_Element43 [copper] = part_of(HFSSDesign1_43) in module63
  HFSSDesign1_44 = component(HFSSDesign1, 3D_Component_File_Path=C:/Users/vemana/Desktop/alphabeta_HELIOS_Footprint.a3dcomp, dy=Len_64, dz=Wid_64, beta=beta64, alpha=alpha64)
  Reflector_Element44 [copper] = part_of(HFSSDesign1_44) in module64
  HFSSDesign1_45 = component(HFSSDesign1, 3D_Component_File_Path=C:/Users/vemana/Desktop/alphabeta_HELIOS_Footprint.a3dcomp, dy=Len_65, dz=Wid_65, beta=beta65, alpha=alpha65)
  Reflector_Element45 [copper] = part_of(HFSSDesign1_45) in module65
  HFSSDesign1_46 = component(HFSSDesign1, 3D_Component_File_Path=C:/Users/vemana/Desktop/alphabeta_HELIOS_Footprint.a3dcomp, dy=Len_66, dz=Wid_66, beta=beta66, alpha=alpha66)
  Reflector_Element46 [copper] = part_of(HFSSDesign1_46) in module66
  HFSSDesign1_47 = component(HFSSDesign1, 3D_Component_File_Path=C:/Users/vemana/Desktop/alphabeta_HELIOS_Footprint.a3dcomp, dy=Len_67, dz=Wid_67, beta=beta67, alpha=alpha67)
  Reflector_Element47 [copper] = part_of(HFSSDesign1_47) in module67
  HFSSDesign1_48 = component(HFSSDesign1, 3D_Component_File_Path=C:/Users/vemana/Desktop/alphabeta_HELIOS_Footprint.a3dcomp, dy=Len_68, dz=Wid_68, beta=beta68, alpha=alpha68)
  Reflector_Element48 [copper] = part_of(HFSSDesign1_48) in module68
  HFSSDesign1_49 = component(HFSSDesign1, 3D_Component_File_Path=C:/Users/vemana/Desktop/alphabeta_HELIOS_Footprint.a3dcomp, dy=Len_71, dz=Wid_71, beta=beta71, alpha=alpha71)
  Reflector_Element49 [copper] = part_of(HFSSDesign1_49) in module71
  HFSSDesign1_50 = component(HFSSDesign1, 3D_Component_File_Path=C:/Users/vemana/Desktop/alphabeta_HELIOS_Footprint.a3dcomp, dy=Len_72, dz=Wid_72, beta=beta72, alpha=alpha72)
  Reflector_Element50 [copper] = part_of(HFSSDesign1_50) in module72
  HFSSDesign1_51 = component(HFSSDesign1, 3D_Component_File_Path=C:/Users/vemana/Desktop/alphabeta_HELIOS_Footprint.a3dcomp, dy=Len_73, dz=Wid_73, beta=beta73, alpha=alpha73)
  Reflector_Element51 [copper] = part_of(HFSSDesign1_51) in module73
  HFSSDesign1_52 = component(HFSSDesign1, 3D_Component_File_Path=C:/Users/vemana/Desktop/alphabeta_HELIOS_Footprint.a3dcomp, dy=Len_74, dz=Wid_74, beta=beta74, alpha=alpha74)
  Reflector_Element52 [copper] = part_of(HFSSDesign1_52) in module74
  HFSSDesign1_53 = component(HFSSDesign1, 3D_Component_File_Path=C:/Users/vemana/Desktop/alphabeta_HELIOS_Footprint.a3dcomp, dy=Len_75, dz=Wid_75, beta=beta75, alpha=alpha75)
  Reflector_Element53 [copper] = part_of(HFSSDesign1_53) in module75
  HFSSDesign1_54 = component(HFSSDesign1, 3D_Component_File_Path=C:/Users/vemana/Desktop/alphabeta_HELIOS_Footprint.a3dcomp, dy=Len_76, dz=Wid_76, beta=beta76, alpha=alpha76)
  Reflector_Element54 [copper] = part_of(HFSSDesign1_54) in module76
  HFSSDesign1_55 = component(HFSSDesign1, 3D_Component_File_Path=C:/Users/vemana/Desktop/alphabeta_HELIOS_Footprint.a3dcomp, dy=Len_77, dz=Wid_77, beta=beta77, alpha=alpha77)
  Reflector_Element55 [copper] = part_of(HFSSDesign1_55) in module77
  HFSSDesign1_56 = component(HFSSDesign1, 3D_Component_File_Path=C:/Users/vemana/Desktop/alphabeta_HELIOS_Footprint.a3dcomp, dy=Len_78, dz=Wid_78, beta=beta78, alpha=alpha78)
  Reflector_Element56 [copper] = part_of(HFSSDesign1_56) in module78
  HFSSDesign1_57 = component(HFSSDesign1, 3D_Component_File_Path=C:/Users/vemana/Desktop/alphabeta_HELIOS_Footprint.a3dcomp, dy=Len_81, dz=Wid_81, beta=beta81, alpha=alpha81)
  Reflector_Element57 [copper] = part_of(HFSSDesign1_57) in module81
  HFSSDesign1_58 = component(HFSSDesign1, 3D_Component_File_Path=C:/Users/vemana/Desktop/alphabeta_HELIOS_Footprint.a3dcomp, dy=Len_82, dz=Wid_82, beta=beta82, alpha=alpha82)
  Reflector_Element58 [copper] = part_of(HFSSDesign1_58) in module82
  HFSSDesign1_59 = component(HFSSDesign1, 3D_Component_File_Path=C:/Users/vemana/Desktop/alphabeta_HELIOS_Footprint.a3dcomp, dy=Len_83, dz=Wid_83, beta=beta83, alpha=alpha83)
  Reflector_Element59 [copper] = part_of(HFSSDesign1_59) in module83
  HFSSDesign1_60 = component(HFSSDesign1, 3D_Component_File_Path=C:/Users/vemana/Desktop/alphabeta_HELIOS_Footprint.a3dcomp, dy=Len_84, dz=Wid_84, beta=beta84, alpha=alpha84)
  Reflector_Element60 [copper] = part_of(HFSSDesign1_60) in module84
  HFSSDesign1_61 = component(HFSSDesign1, 3D_Component_File_Path=C:/Users/vemana/Desktop/alphabeta_HELIOS_Footprint.a3dcomp, dy=Len_85, dz=Wid_85, beta=beta85, alpha=alpha85)
  Reflector_Element61 [copper] = part_of(HFSSDesign1_61) in module85
  HFSSDesign1_62 = component(HFSSDesign1, 3D_Component_File_Path=C:/Users/vemana/Desktop/alphabeta_HELIOS_Footprint.a3dcomp, dy=Len_86, dz=Wid_86, beta=beta86, alpha=alpha86)
  Reflector_Element62 [copper] = part_of(HFSSDesign1_62) in module86
  HFSSDesign1_63 = component(HFSSDesign1, 3D_Component_File_Path=C:/Users/vemana/Desktop/alphabeta_HELIOS_Footprint.a3dcomp, dy=Len_87, dz=Wid_87, beta=beta87, alpha=alpha87)
  Reflector_Element63 [copper] = part_of(HFSSDesign1_63) in module87
  HFSSDesign1_64 = component(HFSSDesign1, 3D_Component_File_Path=C:/Users/vemana/Desktop/alphabeta_HELIOS_Footprint.a3dcomp, dy=Len_88, dz=Wid_88, beta=beta88, alpha=alpha88)
  Reflector_Element64 [copper] = part_of(HFSSDesign1_64) in module88
boundaries and excitations:
  HFSSDesign1_1_SBRRegion1: Hybrid Region Objects=Reflector_Element Type=SBR+
  HFSSDesign1_1_FiniteCond1: Finite Conductivity Objects=Reflector_Element UseMaterial Material=HFSSDesign1_1:copper IsInternal
  HFSSDesign1_2_SBRRegion1: Hybrid Region Objects=Reflector_Element2 Type=SBR+
  HFSSDesign1_2_FiniteCond1: Finite Conductivity Objects=Reflector_Element2 UseMaterial Material=HFSSDesign1_2:copper IsInternal
  HFSSDesign1_3_SBRRegion1: Hybrid Region Objects=Reflector_Element3 Type=SBR+
  HFSSDesign1_3_FiniteCond1: Finite Conductivity Objects=Reflector_Element3 UseMaterial Material=HFSSDesign1_3:copper IsInternal
  HFSSDesign1_4_SBRRegion1: Hybrid Region Objects=Reflector_Element4 Type=SBR+
  HFSSDesign1_4_FiniteCond1: Finite Conductivity Objects=Reflector_Element4 UseMaterial Material=HFSSDesign1_4:copper IsInternal
  HFSSDesign1_5_SBRRegion1: Hybrid Region Objects=Reflector_Element5 Type=SBR+
  HFSSDesign1_5_FiniteCond1: Finite Conductivity Objects=Reflector_Element5 UseMaterial Material=HFSSDesign1_5:copper IsInternal
  HFSSDesign1_6_SBRRegion1: Hybrid Region Objects=Reflector_Element6 Type=SBR+
  HFSSDesign1_6_FiniteCond1: Finite Conductivity Objects=Reflector_Element6 UseMaterial Material=HFSSDesign1_6:copper IsInternal
  HFSSDesign1_7_SBRRegion1: Hybrid Region Objects=Reflector_Element7 Type=SBR+
  HFSSDesign1_7_FiniteCond1: Finite Conductivity Objects=Reflector_Element7 UseMaterial Material=HFSSDesign1_7:copper IsInternal
  HFSSDesign1_8_SBRRegion1: Hybrid Region Objects=Reflector_Element8 Type=SBR+
  HFSSDesign1_8_FiniteCond1: Finite Conductivity Objects=Reflector_Element8 UseMaterial Material=HFSSDesign1_8:copper IsInternal
  HFSSDesign1_9_SBRRegion1: Hybrid Region Objects=Reflector_Element9 Type=SBR+
  HFSSDesign1_9_FiniteCond1: Finite Conductivity Objects=Reflector_Element9 UseMaterial Material=HFSSDesign1_9:copper IsInternal
  HFSSDesign1_10_SBRRegion1: Hybrid Region Objects=Reflector_Element10 Type=SBR+
  HFSSDesign1_10_FiniteCond1: Finite Conductivity Objects=Reflector_Element10 UseMaterial Material=HFSSDesign1_10:copper IsInternal
  HFSSDesign1_11_SBRRegion1: Hybrid Region Objects=Reflector_Element11 Type=SBR+
  HFSSDesign1_11_FiniteCond1: Finite Conductivity Objects=Reflector_Element11 UseMaterial Material=HFSSDesign1_11:copper IsInternal
  HFSSDesign1_12_SBRRegion1: Hybrid Region Objects=Reflector_Element12 Type=SBR+
  HFSSDesign1_12_FiniteCond1: Finite Conductivity Objects=Reflector_Element12 UseMaterial Material=HFSSDesign1_12:copper IsInternal
  HFSSDesign1_13_SBRRegion1: Hybrid Region Objects=Reflector_Element13 Type=SBR+
  HFSSDesign1_13_FiniteCond1: Finite Conductivity Objects=Reflector_Element13 UseMaterial Material=HFSSDesign1_13:copper IsInternal
  HFSSDesign1_14_SBRRegion1: Hybrid Region Objects=Reflector_Element14 Type=SBR+
  HFSSDesign1_14_FiniteCond1: Finite Conductivity Objects=Reflector_Element14 UseMaterial Material=HFSSDesign1_14:copper IsInternal
  HFSSDesign1_15_SBRRegion1: Hybrid Region Objects=Reflector_Element15 Type=SBR+
  HFSSDesign1_15_FiniteCond1: Finite Conductivity Objects=Reflector_Element15 UseMaterial Material=HFSSDesign1_15:copper IsInternal
  HFSSDesign1_16_SBRRegion1: Hybrid Region Objects=Reflector_Element16 Type=SBR+
  HFSSDesign1_16_FiniteCond1: Finite Conductivity Objects=Reflector_Element16 UseMaterial Material=HFSSDesign1_16:copper IsInternal
  HFSSDesign1_17_SBRRegion1: Hybrid Region Objects=Reflector_Element17 Type=SBR+
  HFSSDesign1_17_FiniteCond1: Finite Conductivity Objects=Reflector_Element17 UseMaterial Material=HFSSDesign1_17:copper IsInternal
  HFSSDesign1_18_SBRRegion1: Hybrid Region Objects=Reflector_Element18 Type=SBR+
  HFSSDesign1_18_FiniteCond1: Finite Conductivity Objects=Reflector_Element18 UseMaterial Material=HFSSDesign1_18:copper IsInternal
  HFSSDesign1_19_SBRRegion1: Hybrid Region Objects=Reflector_Element19 Type=SBR+
  HFSSDesign1_19_FiniteCond1: Finite Conductivity Objects=Reflector_Element19 UseMaterial Material=HFSSDesign1_19:copper IsInternal
  HFSSDesign1_20_SBRRegion1: Hybrid Region Objects=Reflector_Element20 Type=SBR+
  HFSSDesign1_20_FiniteCond1: Finite Conductivity Objects=Reflector_Element20 UseMaterial Material=HFSSDesign1_20:copper IsInternal
  HFSSDesign1_21_SBRRegion1: Hybrid Region Objects=Reflector_Element21 Type=SBR+
  HFSSDesign1_21_FiniteCond1: Finite Conductivity Objects=Reflector_Element21 UseMaterial Material=HFSSDesign1_21:copper IsInternal
  HFSSDesign1_22_SBRRegion1: Hybrid Region Objects=Reflector_Element22 Type=SBR+
  HFSSDesign1_22_FiniteCond1: Finite Conductivity Objects=Reflector_Element22 UseMaterial Material=HFSSDesign1_22:copper IsInternal
  HFSSDesign1_23_SBRRegion1: Hybrid Region Objects=Reflector_Element23 Type=SBR+
  HFSSDesign1_23_FiniteCond1: Finite Conductivity Objects=Reflector_Element23 UseMaterial Material=HFSSDesign1_23:copper IsInternal
  HFSSDesign1_24_SBRRegion1: Hybrid Region Objects=Reflector_Element24 Type=SBR+
  HFSSDesign1_24_FiniteCond1: Finite Conductivity Objects=Reflector_Element24 UseMaterial Material=HFSSDesign1_24:copper IsInternal
  HFSSDesign1_25_SBRRegion1: Hybrid Region Objects=Reflector_Element25 Type=SBR+
  HFSSDesign1_25_FiniteCond1: Finite Conductivity Objects=Reflector_Element25 UseMaterial Material=HFSSDesign1_25:copper IsInternal
  HFSSDesign1_26_SBRRegion1: Hybrid Region Objects=Reflector_Element26 Type=SBR+
  HFSSDesign1_26_FiniteCond1: Finite Conductivity Objects=Reflector_Element26 UseMaterial Material=HFSSDesign1_26:copper IsInternal
  HFSSDesign1_27_SBRRegion1: Hybrid Region Objects=Reflector_Element27 Type=SBR+
  HFSSDesign1_27_FiniteCond1: Finite Conductivity Objects=Reflector_Element27 UseMaterial Material=HFSSDesign1_27:copper IsInternal
  HFSSDesign1_28_SBRRegion1: Hybrid Region Objects=Reflector_Element28 Type=SBR+
  HFSSDesign1_28_FiniteCond1: Finite Conductivity Objects=Reflector_Element28 UseMaterial Material=HFSSDesign1_28:copper IsInternal
  HFSSDesign1_29_SBRRegion1: Hybrid Region Objects=Reflector_Element29 Type=SBR+
  HFSSDesign1_29_FiniteCond1: Finite Conductivity Objects=Reflector_Element29 UseMaterial Material=HFSSDesign1_29:copper IsInternal
  HFSSDesign1_30_SBRRegion1: Hybrid Region Objects=Reflector_Element30 Type=SBR+
  HFSSDesign1_30_FiniteCond1: Finite Conductivity Objects=Reflector_Element30 UseMaterial Material=HFSSDesign1_30:copper IsInternal
  HFSSDesign1_31_SBRRegion1: Hybrid Region Objects=Reflector_Element31 Type=SBR+
  HFSSDesign1_31_FiniteCond1: Finite Conductivity Objects=Reflector_Element31 UseMaterial Material=HFSSDesign1_31:copper IsInternal
  HFSSDesign1_32_SBRRegion1: Hybrid Region Objects=Reflector_Element32 Type=SBR+
  HFSSDesign1_32_FiniteCond1: Finite Conductivity Objects=Reflector_Element32 UseMaterial Material=HFSSDesign1_32:copper IsInternal
  HFSSDesign1_33_SBRRegion1: Hybrid Region Objects=Reflector_Element33 Type=SBR+
  HFSSDesign1_33_FiniteCond1: Finite Conductivity Objects=Reflector_Element33 UseMaterial Material=HFSSDesign1_33:copper IsInternal
  HFSSDesign1_34_SBRRegion1: Hybrid Region Objects=Reflector_Element34 Type=SBR+
  HFSSDesign1_34_FiniteCond1: Finite Conductivity Objects=Reflector_Element34 UseMaterial Material=HFSSDesign1_34:copper IsInternal
  HFSSDesign1_35_SBRRegion1: Hybrid Region Objects=Reflector_Element35 Type=SBR+
  HFSSDesign1_35_FiniteCond1: Finite Conductivity Objects=Reflector_Element35 UseMaterial Material=HFSSDesign1_35:copper IsInternal
  HFSSDesign1_36_SBRRegion1: Hybrid Region Objects=Reflector_Element36 Type=SBR+
  HFSSDesign1_36_FiniteCond1: Finite Conductivity Objects=Reflector_Element36 UseMaterial Material=HFSSDesign1_36:copper IsInternal
  HFSSDesign1_37_SBRRegion1: Hybrid Region Objects=Reflector_Element37 Type=SBR+
  HFSSDesign1_37_FiniteCond1: Finite Conductivity Objects=Reflector_Element37 UseMaterial Material=HFSSDesign1_37:copper IsInternal
  HFSSDesign1_38_SBRRegion1: Hybrid Region Objects=Reflector_Element38 Type=SBR+
  HFSSDesign1_38_FiniteCond1: Finite Conductivity Objects=Reflector_Element38 UseMaterial Material=HFSSDesign1_38:copper IsInternal
  HFSSDesign1_39_SBRRegion1: Hybrid Region Objects=Reflector_Element39 Type=SBR+
  HFSSDesign1_39_FiniteCond1: Finite Conductivity Objects=Reflector_Element39 UseMaterial Material=HFSSDesign1_39:copper IsInternal
  HFSSDesign1_40_SBRRegion1: Hybrid Region Objects=Reflector_Element40 Type=SBR+
  HFSSDesign1_40_FiniteCond1: Finite Conductivity Objects=Reflector_Element40 UseMaterial Material=HFSSDesign1_40:copper IsInternal
  HFSSDesign1_41_SBRRegion1: Hybrid Region Objects=Reflector_Element41 Type=SBR+
  HFSSDesign1_41_FiniteCond1: Finite Conductivity Objects=Reflector_Element41 UseMaterial Material=HFSSDesign1_41:copper IsInternal
  HFSSDesign1_42_SBRRegion1: Hybrid Region Objects=Reflector_Element42 Type=SBR+
  HFSSDesign1_42_FiniteCond1: Finite Conductivity Objects=Reflector_Element42 UseMaterial Material=HFSSDesign1_42:copper IsInternal
  HFSSDesign1_43_SBRRegion1: Hybrid Region Objects=Reflector_Element43 Type=SBR+
  HFSSDesign1_43_FiniteCond1: Finite Conductivity Objects=Reflector_Element43 UseMaterial Material=HFSSDesign1_43:copper IsInternal
  HFSSDesign1_44_SBRRegion1: Hybrid Region Objects=Reflector_Element44 Type=SBR+
  HFSSDesign1_44_FiniteCond1: Finite Conductivity Objects=Reflector_Element44 UseMaterial Material=HFSSDesign1_44:copper IsInternal
  HFSSDesign1_45_SBRRegion1: Hybrid Region Objects=Reflector_Element45 Type=SBR+
  HFSSDesign1_45_FiniteCond1: Finite Conductivity Objects=Reflector_Element45 UseMaterial Material=HFSSDesign1_45:copper IsInternal
  HFSSDesign1_46_SBRRegion1: Hybrid Region Objects=Reflector_Element46 Type=SBR+
  HFSSDesign1_46_FiniteCond1: Finite Conductivity Objects=Reflector_Element46 UseMaterial Material=HFSSDesign1_46:copper IsInternal
  HFSSDesign1_47_SBRRegion1: Hybrid Region Objects=Reflector_Element47 Type=SBR+
  HFSSDesign1_47_FiniteCond1: Finite Conductivity Objects=Reflector_Element47 UseMaterial Material=HFSSDesign1_47:copper IsInternal
  HFSSDesign1_48_SBRRegion1: Hybrid Region Objects=Reflector_Element48 Type=SBR+
  HFSSDesign1_48_FiniteCond1: Finite Conductivity Objects=Reflector_Element48 UseMaterial Material=HFSSDesign1_48:copper IsInternal
  HFSSDesign1_49_SBRRegion1: Hybrid Region Objects=Reflector_Element49 Type=SBR+
  HFSSDesign1_49_FiniteCond1: Finite Conductivity Objects=Reflector_Element49 UseMaterial Material=HFSSDesign1_49:copper IsInternal
  HFSSDesign1_50_SBRRegion1: Hybrid Region Objects=Reflector_Element50 Type=SBR+
  HFSSDesign1_50_FiniteCond1: Finite Conductivity Objects=Reflector_Element50 UseMaterial Material=HFSSDesign1_50:copper IsInternal
  HFSSDesign1_51_SBRRegion1: Hybrid Region Objects=Reflector_Element51 Type=SBR+
  HFSSDesign1_51_FiniteCond1: Finite Conductivity Objects=Reflector_Element51 UseMaterial Material=HFSSDesign1_51:copper IsInternal
  HFSSDesign1_52_SBRRegion1: Hybrid Region Objects=Reflector_Element52 Type=SBR+
  HFSSDesign1_52_FiniteCond1: Finite Conductivity Objects=Reflector_Element52 UseMaterial Material=HFSSDesign1_52:copper IsInternal
  HFSSDesign1_53_SBRRegion1: Hybrid Region Objects=Reflector_Element53 Type=SBR+
  HFSSDesign1_53_FiniteCond1: Finite Conductivity Objects=Reflector_Element53 UseMaterial Material=HFSSDesign1_53:copper IsInternal
  HFSSDesign1_54_SBRRegion1: Hybrid Region Objects=Reflector_Element54 Type=SBR+
  HFSSDesign1_54_FiniteCond1: Finite Conductivity Objects=Reflector_Element54 UseMaterial Material=HFSSDesign1_54:copper IsInternal
  HFSSDesign1_55_SBRRegion1: Hybrid Region Objects=Reflector_Element55 Type=SBR+
  HFSSDesign1_55_FiniteCond1: Finite Conductivity Objects=Reflector_Element55 UseMaterial Material=HFSSDesign1_55:copper IsInternal
  HFSSDesign1_56_SBRRegion1: Hybrid Region Objects=Reflector_Element56 Type=SBR+
  HFSSDesign1_56_FiniteCond1: Finite Conductivity Objects=Reflector_Element56 UseMaterial Material=HFSSDesign1_56:copper IsInternal
  HFSSDesign1_57_SBRRegion1: Hybrid Region Objects=Reflector_Element57 Type=SBR+
  HFSSDesign1_57_FiniteCond1: Finite Conductivity Objects=Reflector_Element57 UseMaterial Material=HFSSDesign1_57:copper IsInternal
  HFSSDesign1_58_SBRRegion1: Hybrid Region Objects=Reflector_Element58 Type=SBR+
  HFSSDesign1_58_FiniteCond1: Finite Conductivity Objects=Reflector_Element58 UseMaterial Material=HFSSDesign1_58:copper IsInternal
  HFSSDesign1_59_SBRRegion1: Hybrid Region Objects=Reflector_Element59 Type=SBR+
  HFSSDesign1_59_FiniteCond1: Finite Conductivity Objects=Reflector_Element59 UseMaterial Material=HFSSDesign1_59:copper IsInternal
  HFSSDesign1_60_SBRRegion1: Hybrid Region Objects=Reflector_Element60 Type=SBR+
  HFSSDesign1_60_FiniteCond1: Finite Conductivity Objects=Reflector_Element60 UseMaterial Material=HFSSDesign1_60:copper IsInternal
  HFSSDesign1_61_SBRRegion1: Hybrid Region Objects=Reflector_Element61 Type=SBR+
  HFSSDesign1_61_FiniteCond1: Finite Conductivity Objects=Reflector_Element61 UseMaterial Material=HFSSDesign1_61:copper IsInternal
  HFSSDesign1_62_SBRRegion1: Hybrid Region Objects=Reflector_Element62 Type=SBR+
  HFSSDesign1_62_FiniteCond1: Finite Conductivity Objects=Reflector_Element62 UseMaterial Material=HFSSDesign1_62:copper IsInternal
  HFSSDesign1_63_SBRRegion1: Hybrid Region Objects=Reflector_Element63 Type=SBR+
  HFSSDesign1_63_FiniteCond1: Finite Conductivity Objects=Reflector_Element63 UseMaterial Material=HFSSDesign1_63:copper IsInternal
  HFSSDesign1_64_SBRRegion1: Hybrid Region Objects=Reflector_Element64 Type=SBR+
  HFSSDesign1_64_FiniteCond1: Finite Conductivity Objects=Reflector_Element64 UseMaterial Material=HFSSDesign1_64:copper IsInternal
  IncPWave1: Plane Incident Wave PhiStart="(180+az_angle*180/pi) deg" PhiStop="(180+az_angle*180/pi) deg" PhiPoints=1 ThetaStart="-el_angle*180/pi deg" ThetaStop="-el_angle*180/pi deg" ThetaPoints=1 EoPhi=1 EoTheta=0 OriginX=spacing_x OriginY=spacing_y OriginZ=spacing_z IsPropagating
setups:
  Setup1: HfssDriven RayDensityPerWavelength=4 MaxNumberOfBounces=5 RadiationSetup=158 PTDUTDSimulationSettings="PTD Correction + UTD Rays" PTDEdgeDensity=20 ComputeFarFields
    sweep Sweep: point 28GHz;
source amplitudes:
  IncPWave1:1: 1 0deg
radiation setups:
  FarField_Setup: Infinite Sphere Theta=0deg..180deg step 2deg Phi=-90deg..90deg step 2deg CoordSystem=central_RIS_Orientation
reports:
  FarField_Report: dB(RCSTotal) vs Phi, Theta on Setup1 : Sweep, FarField_Setup [Freq=28GHz IWavePhi=180deg IWaveTheta=-90deg]
