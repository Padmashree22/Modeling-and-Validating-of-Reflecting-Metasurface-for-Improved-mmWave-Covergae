# Ansys Electronics Desktop project, version 2021.2
materials:
  vacuum: permittivity=1
  pec: conductivity=1e+30

design HFSSDesign1 (HFSS, SBR+, model units mm)
variables:
  alpha11 = 2deg
  beta11 = 2deg
  Len_11 = Length
  Wid_11 = Width
  spacing_magnitude = 1meter
  el_angle = 90deg
  az_angle = 0deg
  spacing_x = spacing_magnitude*sin(el_angle*pi/180 deg)*cos(az_angle*pi/180 deg)
  spacing_y = spacing_magnitude*sin(el_angle*pi/180 deg)*sin(-1*az_angle*pi/180 deg)
  spacing_z = spacing_magnitude*cos(el_angle*pi/180 deg)
  Length = 30cm
  Width = 30cm
  alpha12 = alpha11+delta
  beta12 = beta11+delta
  Len_12 = Len_11
  Wid_12 = Wid_11
  alpha21 = alpha11
  beta21 = beta11
  Len_21 = Len_11
  Wid_21 = Wid_11
  alpha22 = alpha12
  beta22 = beta12
  Len_22 = Len_12
  Wid_22 = Wid_12
  Len_13 = Len_12
  alpha13 = alpha12+delta
  beta13 = beta12+delta
  Wid_13 = Wid_12
  alpha23 = alpha13
  beta23 = beta13
  Len_23 = Len_13
  Wid_23 = Wid_13
  alpha31 = alpha21
  beta31 = beta21
  Len_31 = Len_21
  Wid_31 = Wid_21
  alpha32 = alpha22
  beta32 = beta22
  Len_32 = Len_22
  Wid_32 = WId_22
  alpha33 = alpha23
  beta33 = beta23
  Len_33 = Len_23
  Wid_33 = Wid_23
  delta = 0deg
  n = 3
geometry:
  coordinate_system module11 = origin=(0mm, 0mm, 0mm) x=(1mm, 0mm, 0mm) y=(0mm, 1mm, 0mm)
  coordinate_system module12 = origin=(0mm, Length, 0mm) x=(1mm, 0mm, 0mm) y=(0mm, 1mm, 0mm)
  coordinate_system module21 = origin=(0mm, 0mm, Width) x=(1mm, 0mm, 0mm) y=(0mm, 1mm, 0mm)
  coordinate_system module22 = origin=(0mm, Length, Width) x=(1mm, 0mm, 0mm) y=(0mm, 1mm, 0mm)
  coordinate_system module13 = origin=(0mm, 2*Length, 0mm) x=(1mm, 0mm, 0mm) y=(0mm, 1mm, 0mm)
  coordinate_system module23 = origin=(0mm, 2*Length, Width) x=(1mm, 0mm, 0mm) y=(0mm, 1mm, 0mm)
  coordinate_system module31 = origin=(0mm, 0mm, 2*Width) x=(1mm, 0mm, 0mm) y=(0mm, 1mm, 0mm)
  coordinate_system module32 = origin=(0mm, Length, 2*Width) x=(1mm, 0mm, 0mm) y=(0mm, 1mm, 0mm)
  coordinate_system module33 = origin=(0mm, 2*Length, 2*Width) x=(1mm, 0mm, 0mm) y=(0mm, 1mm, 0mm)
  HFSSDesign1_1 = component(HFSSDesign1, 3D_Component_File_Path=C:/Users/vemana/Desktop/Modified_HELIOS_Footprint.a3dcomp, beta=beta11, dy=Len_11, alpha=alpha11, dz=Wid_11)
  Reflector_Element [copper] = part_of(HFSSDesign1_1) in module11
  HFSSDesign1_2 = component(HFSSDesign1, 3D_Component_File_Path=C:/Users/vemana/Desktop/Modified_HELIOS_Footprint.a3dcomp, beta=beta12, dy=Len_12, alpha=alpha12, dz=Wid_12)
  Reflector_Element2 [copper] = part_of(HFSSDesign1_2) in module12
  HFSSDesign1_3 = component(HFSSDesign1, 3D_Component_File_Path=C:/Users/vemana/Desktop/Modified_HELIOS_Footprint.a3dcomp, beta=beta13, dy=Len_13, alpha=alpha13, dz=Wid_13)
  Reflector_Element3 [copper] = part_of(HFSSDesign1_3) in module13
  HFSSDesign1_4 = component(HFSSDesign1, 3D_Component_File_Path=C:/Users/vemana/Desktop/Modified_HELIOS_Footprint.a3dcomp, beta=beta21, dy=Len_21, alpha=alpha21, dz=Wid_21)
  Reflector_Element4 [copper] = part_of(HFSSDesign1_4) in module21
  HFSSDesign1_5 = component(HFSSDesign1, 3D_Component_File_Path=C:/Users/vemana/Desktop/Modified_HELIOS_Footprint.a3dcomp, beta=beta22, dy=Len_22, alpha=alpha22, dz=Wid_22)
  Reflector_Element5 [copper] = part_of(HFSSDesign1_5) in module22
  HFSSDesign1_6 = component(HFSSDesign1, 3D_Component_File_Path=C:/Users/vemana/Desktop/Modified_HELIOS_Footprint.a3dcomp, beta=beta23, dy=Len_23, alpha=alpha23, dz=Wid_23)
  Reflector_Element6 [copper] = part_of(HFSSDesign1_6) in module23
  HFSSDesign1_7 = component(HFSSDesign1, 3D_Component_File_Path=C:/Users/vemana/Desktop/Modified_HELIOS_Footprint.a3dcomp, beta=beta31, dy=Len_31, alpha=alpha31, dz=Wid_31)
  Reflector_Element7 [copper] = part_of(HFSSDesign1_7) in module31
  HFSSDesign1_8 = component(HFSSDesign1, 3D_Component_File_Path=C:/Users/vemana/Desktop/Modified_HELIOS_Footprint.a3dcomp, beta=beta32, dy=Len_32, alpha=alpha32, dz=Wid_32)
  Reflector_Element8 [copper] = part_of(HFSSDesign1_8) in module32
  HFSSDesign1_9 = component(HFSSDesign1, 3D_Component_File_Path=C:/Users/vemana/Desktop/Modified_HELIOS_Footprint.a3dcomp, beta=beta33, dy=Len_33, alpha=alpha33, dz=Wid_33)
  Reflector_Element9 [copper] = part_of(HFSSDesign1_9) in module33
boundaries and excitations:
  HFSSDesign1_1_SBRRegion1: Hybrid Region Objects=Reflector_Element Type=SBR+
  HFSSDesign1_1_FiniteCond1: Finite Conductivity Objects=Reflector_Element UseMaterial Material=HFSSDesign1_1:copper IsInternal
  HFSSDesign1_2_SBRRegion1: Hybrid Region Objects=Reflector_Element2 Type=SBR+
  HFSSDesign1_2_FiniteCond1: Finite Conductivity Objects=Reflector_Element2 UseMaterial Material=HFSSDesign1_2:copper IsInternal
  HFSSDesign1_3_SBRRegion1: Hybrid Region Objects=Reflector_Element3 Type=SBR+
  HFSSDesign1_3_FiniteCond1: Finite Conductivity Objects=Reflector_Element3 UseMaterial Material=HFSSDesign1_3:copper IsInternal
  HFSSDesign1_4_SBRRegion1: Hybrid Region Objects=Reflector_Element4 Type=SBR+
  HFSSDesign1_4_FiniteCond1: Finite Conductivity Objects=Reflector_Element4 UseMaterial Material=HFSSDesign1_4:copper IsInternal
  HFSSDesign1_5_SBRRegion1: Hybrid Region Objects=Reflector_Element5 Type=SBR+
  HFSSDesign1_5_FiniteCond1: Finite Conductivity Objects=Reflector_Element5 UseMaterial Material=HFSSDesign1_5:copper IsInternal
  HFSSDesign1_6_SBRRegion1: Hybrid Region Objects=Reflector_Element6 Type=SBR+
  HFSSDesign1_6_FiniteCond1: Finite Conductivity Objects=Reflector_Element6 UseMaterial Material=HFSSDesign1_6:copper IsInternal
  HFSSDesign1_7_SBRRegion1: Hybrid Region Objects=Reflector_Element7 Type=SBR+
  HFSSDesign1_7_FiniteCond1: Finite Conductivity Objects=Reflector_Element7 UseMaterial Material=HFSSDesign1_7:copper IsInternal
  HFSSDesign1_8_SBRRegion1: Hybrid Region Objects=Reflector_Element8 Type=SBR+
  HFSSDesign1_8_FiniteCond1: Finite Conductivity Objects=Reflector_Element8 UseMaterial Material=HFSSDesign1_8:copper IsInternal
  HFSSDesign1_9_SBRRegion1: Hybrid Region Objects=Reflector_Element9 Type=SBR+
  HFSSDesign1_9_FiniteCond1: Finite Conductivity Objects=Reflector_Element9 UseMaterial Material=HFSSDesign1_9:copper IsInternal
  IncPWave1: Plane Incident Wave PhiStart="(180+az_angle*180/pi) deg" PhiStop="(180+az_angle*180/pi) deg" PhiPoints=1 ThetaStart="-el_angle*180/pi deg" ThetaStop="-el_angle*180/pi deg" ThetaPoints=1 EoPhi=1 EoTheta=0 OriginX=spacing_x OriginY=spacing_y OriginZ=spacing_z IsPropagating
mesh:
  HFSSDesign1_1_SBRCurvExtr1: CurvatureExtraction Objects=Reflector_Element DisableForFacetedSurfaces
  HFSSDesign1_2_SBRCurvExtr1: CurvatureExtraction Objects=Reflector_Element2 DisableForFacetedSurfaces
  HFSSDesign1_3_SBRCurvExtr1: CurvatureExtraction Objects=Reflector_Element3 DisableForFacetedSurfaces
  HFSSDesign1_4_SBRCurvExtr1: CurvatureExtraction Objects=Reflector_Element4 DisableForFacetedSurfaces
  HFSSDesign1_5_SBRCurvExtr1: CurvatureExtraction Objects=Reflector_Element5 DisableForFacetedSurfaces
  HFSSDesign1_6_SBRCurvExtr1: CurvatureExtraction Objects=Reflector_Element6 DisableForFacetedSurfaces
  HFSSDesign1_7_SBRCurvExtr1: CurvatureExtraction Objects=Reflector_Element7 DisableForFacetedSurfaces
  HFSSDesign1_8_SBRCurvExtr1: CurvatureExtraction Objects=Reflector_Element8 DisableForFacetedSurfaces
  HFSSDesign1_9_SBRCurvExtr1: CurvatureExtraction Objects=Reflector_Element9 DisableForFacetedSurfaces
setups:
  Setup1: HfssDriven RayDensityPerWavelength=4 MaxNumberOfBounces=5 RadiationSetup=32 PTDUTDSimulationSettings="PTD Correction + UTD Rays" PTDEdgeDensity=20 ComputeFarFields
    sweep Sweep: point 28GHz;
source amplitudes:
  IncPWave1:1: 1 0deg
radiation setups:
  FarField_Setup: Infinite Sphere Theta=0deg..180deg step 2deg Phi=-90deg..90deg step 2deg CoordSystem=module11
reports:
  FarField_Report: dB(RCSTotal) vs Phi, Theta on Setup1 : Sweep, FarField_Setup [Freq=28GHz IWavePhi=180deg IWaveTheta=-90deg]
