# Ansys Electronics Desktop project, version 2021.2
materials:
  vacuum: permittivity=1
  pec: conductivity=1e+30

design HFSSDesign1 (HFSS, SBR+, model units mm)
variables:
  alpha11 = beta11
  beta11 = 10deg
  Len_11 = Length
  Wid_11 = Width
  spacing_magnitude = 1meter
  el_angle = 100deg
  az_angle = 10deg
  spacing_x = spacing_magnitude*sin(el_angle*pi/180 deg)*cos(az_angle*pi/180 deg)
  spacing_y = spacing_magnitude*sin(el_angle*pi/180 deg)*sin(-1*az_angle*pi/180 deg)
  spacing_z = spacing_magnitude*cos(el_angle*pi/180 deg)
  Length = 10cm
  Width = 10cm
  alpha12 = alpha11
  beta12 = beta11
  Len_12 = Len_11
  Wid_12 = Wid_11
  alpha21 = alpha11
  beta21 = beta11
  Len_21 = Len_11
  Wid_21 = Wid_11
  alpha22 = alpha12
  beta22 = beta12
  Len_22 = Len_12
  Wid_22 = Wid_12
  Len_13 = Len_12
  alpha13 = alpha12
  beta13 = beta12
  Wid_13 = Wid_12
  alpha23 = alpha13
  beta23 = beta13
  Len_23 = Len_13
  Wid_23 = Wid_13
  alpha31 = alpha21
  beta31 = beta21
  Len_31 = Len_21
  Wid_31 = Wid_21
  alpha32 = alpha22
  beta32 = beta22
  Len_32 = Len_22
  Wid_32 = WId_22
  alpha33 = alpha23
  beta33 = beta23
  Len_33 = Len_23
  Wid_33 = Wid_23
  beta14 = beta13
  Len_14 = Len_13
  Wid_14 = Wid_13
  alpha14 = alpha13
  alpha24 = alpha14
  beta24 = beta14
  Len_24 = Len_14
  Wid_24 = Wid_14
  alpha34 = alpha24
  beta34 = beta24
  Len_34 = Len_24
  Wid_34 = Wid_24
  alpha41 = alpha31
  beta41 = beta31
  Len_41 = Len_31
  Wid_41 = Wid_31
  alpha42 = alpha32
  beta42 = beta32
  Len_42 = Len_32
  Wid_42 = Wid_32
  alpha43 = alpha33
  beta43 = beta33
  Len_43 = Len_33
  Wid_43 = Wid_33
  alpha44 = alpha34
  beta44 = beta34
  Len_44 = Len_34
  Wid_44 = Wid_34
  Len_15 = Len_14
  beta15 = beta14
  alpha15 = alpha14
  Wid_15 = Wid_14
  alpha25 = alpha15
  beta25 = beta15
  Len_25 = Len_15
  Wid_25 = Wid_15
  alpha35 = alpha25
  beta35 = beta25
  Len_35 = Len_25
  Wid_35 = Wid_25
  alpha45 = alpha35
  beta45 = beta35
  Len_45 = Len_35
  Wid_45 = Wid_35
  alpha55 = alpha45
  beta55 = beta45
  Len_55 = Len_45
  Wid_55 = Wid_45
  alpha54 = alpha44
  beta54 = beta44
  Len_54 = Len_44
  Wid_54 = Wid_44
  alpha53 = alpha43
  beta53 = beta43
  Len_53 = Len_43
  Wid_53 = Wid_43
  alpha52 = alpha42
  beta52 = beta42
  Len_52 = Len_42
  Wid_52 = Wid_42
  alpha51 = alpha41
  beta51 = beta41
  Len_51 = Len_41
  Wid_51 = Wid_41
geometry:
  coordinate_system module11 = origin=(0mm, 0mm, 0mm) x=(1mm, 0mm, 0mm) y=(0mm, 1mm, 0mm)
  coordinate_system module12 = origin=(0mm, Length, 0mm) x=(1mm, 0mm, 0mm) y=(0mm, 1mm, 0mm)
  coordinate_system module21 = origin=(0mm, 0mm, Width) x=(1mm, 0mm, 0mm) y=(0mm, 1mm, 0mm)
  coordinate_system module22 = origin=(0mm, Length, Width) x=(1mm, 0mm, 0mm) y=(0mm, 1mm, 0mm)
  coordinate_system module13 = origin=(0mm, 2*Length, 0mm) x=(1mm, 0mm, 0mm) y=(0mm, 1mm, 0mm)
  coordinate_system module23 = origin=(0mm, 2*Length, Width) x=(1mm, 0mm, 0mm) y=(0mm, 1mm, 0mm)
  coordinate_system module31 = origin=(0mm, 0mm, 2*Width) x=(1mm, 0mm, 0mm) y=(0mm, 1mm, 0mm)
  coordinate_system module32 = origin=(0mm, Length, 2*Width) x=(1mm, 0mm, 0mm) y=(0mm, 1mm, 0mm)
  coordinate_system module33 = origin=(0mm, 2*Length, 2*Width) x=(1mm, 0mm, 0mm) y=(0mm, 1mm, 0mm)
  coordinate_system module14 = origin=(0mm, 3*Length, 0mm) x=(1mm, 0mm, 0mm) y=(0mm, 1mm, 0mm)
  coordinate_system module24 = origin=(0mm, 3*Length, Width) x=(1mm, 0mm, 0mm) y=(0mm, 1mm, 0mm)
  coordinate_system module34 = origin=(0mm, 3*Length, 2*Width) x=(1mm, 0mm, 0mm) y=(0mm, 1mm, 0mm)
  coordinate_system module41 = origin=(0mm, 0mm, 3*Width) x=(1mm, 0mm, 0mm) y=(0mm, 1mm, 0mm)
  coordinate_system module42 = origin=(0mm, Length, 3*Width) x=(1mm, 0mm, 0mm) y=(0mm, 1mm, 0mm)
  coordinate_system module43 = origin=(0mm, 2*Length, 3*Width) x=(1mm, 0mm, 0mm) y=(0mm, 1mm, 0mm)
  coordinate_system module44 = origin=(0mm, 3*Length, 3*Width) x=(1mm, 0mm, 0mm) y=(0mm, 1mm, 0mm)
  coordinate_system module15 = origin=(0mm, 4*Length, 0mm) x=(1mm, 0mm, 0mm) y=(0mm, 1mm, 0mm)
  coordinate_system module25 = origin=(0mm, 4*Length, Width) x=(1mm, 0mm, 0mm) y=(0mm, 1mm, 0mm)
  coordinate_system module35 = origin=(0mm, 4*Length, 2*Width) x=(1mm, 0mm, 0mm) y=(0mm, 1mm, 0mm)
  coordinate_system module45 = origin=(0mm, 4*Length, 3*Width) x=(1mm, 0mm, 0mm) y=(0mm, 1mm, 0mm)
  coordinate_system module55 = origin=(0mm, 4*Length, 4*Width) x=(1mm, 0mm, 0mm) y=(0mm, 1mm, 0mm)
  coordinate_system module54 = origin=(0mm, 3*Length, 4*Width) x=(1mm, 0mm, 0mm) y=(0mm, 1mm, 0mm)
  coordinate_system module53 = origin=(0mm, 2*Length, 4*Width) x=(1mm, 0mm, 0mm) y=(0mm, 1mm, 0mm)
  coordinate_system module52 = origin=(0mm, 1*Length, 4*Width) x=(1mm, 0mm, 0mm) y=(0mm, 1mm, 0mm)
  coordinate_system module51 = origin=(0mm, 0mm, 4*Width) x=(1mm, 0mm, 0mm) y=(0mm, 1mm, 0mm)
  HFSSDesign1_1 = component(HFSSDesign1, 3D_Component_File_Path=C:/Users/vemana/Desktop/Modified_HELIOS_Footprint.a3dcomp, dy=Len_11, dz=Wid_11, beta=beta11, alpha=alpha11)
  Reflector_Element [copper] = part_of(HFSSDesign1_1) in module11
  HFSSDesign1_2 = component(HFSSDesign1, 3D_Component_File_Path=C:/Users/vemana/Desktop/Modified_HELIOS_Footprint.a3dcomp, dy=Len_12, dz=Wid_12, beta=beta12, alpha=alpha12)
  Reflector_Element2 [copper] = part_of(HFSSDesign1_2) in module12
  HFSSDesign1_3 = component(HFSSDesign1, 3D_Component_File_Path=C:/Users/vemana/Desktop/Modified_HELIOS_Footprint.a3dcomp, dy=Len_13, dz=Wid_13, beta=beta13, alpha=alpha13)
  Reflector_Element3 [copper] = part_of(HFSSDesign1_3) in module13
  HFSSDesign1_4 = component(HFSSDesign1, 3D_Component_File_Path=C:/Users/vemana/Desktop/Modified_HELIOS_Footprint.a3dcomp, dy=Len_14, dz=Wid_14, beta=beta14, alpha=alpha14)
  Reflector_Element4 [copper] = part_of(HFSSDesign1_4) in module14
  HFSSDesign1_5 = component(HFSSDesign1, 3D_Component_File_Path=C:/Users/vemana/Desktop/Modified_HELIOS_Footprint.a3dcomp, dy=Len_15, dz=Wid_15, beta=beta15, alpha=alpha15)
  Reflector_Element5 [copper] = part_of(HFSSDesign1_5) in module15
  HFSSDesign1_6 = component(HFSSDesign1, 3D_Component_File_Path=C:/Users/vemana/Desktop/Modified_HELIOS_Footprint.a3dcomp, dy=Len_21, dz=Wid_21, beta=beta21, alpha=alpha21)
  Reflector_Element6 [copper] = part_of(HFSSDesign1_6) in module21
  HFSSDesign1_7 = component(HFSSDesign1, 3D_Component_File_Path=C:/Users/vemana/Desktop/Modified_HELIOS_Footprint.a3dcomp, dy=Len_22, dz=Wid_22, beta=beta22, alpha=alpha22)
  Reflector_Element7 [copper] = part_of(HFSSDesign1_7) in module22
  HFSSDesign1_8 = component(HFSSDesign1, 3D_Component_File_Path=C:/Users/vemana/Desktop/Modified_HELIOS_Footprint.a3dcomp, dy=Len_23, dz=Wid_23, beta=beta23, alpha=alpha23)
  Reflector_Element8 [copper] = part_of(HFSSDesign1_8) in module23
  HFSSDesign1_9 = component(HFSSDesign1, 3D_Component_File_Path=C:/Users/vemana/Desktop/Modified_HELIOS_Footprint.a3dcomp, dy=Len_24, dz=Wid_24, beta=beta24, alpha=alpha24)
  Reflector_Element9 [copper] = part_of(HFSSDesign1_9) in module24
  HFSSDesign1_10 = component(HFSSDesign1, 3D_Component_File_Path=C:/Users/vemana/Desktop/Modified_HELIOS_Footprint.a3dcomp, dy=Len_25, dz=Wid_25, beta=beta25, alpha=alpha25)
  Reflector_Element10 [copper] = part_of(HFSSDesign1_10) in module25
  HFSSDesign1_11 = component(HFSSDesign1, 3D_Component_File_Path=C:/Users/vemana/Desktop/Modified_HELIOS_Footprint.a3dcomp, dy=Len_31, dz=Wid_31, beta=beta31, alpha=alpha31)
  Reflector_Element11 [copper] = part_of(HFSSDesign1_11) in module31
  HFSSDesign1_12 = component(HFSSDesign1, 3D_Component_File_Path=C:/Users/vemana/Desktop/Modified_HELIOS_Footprint.a3dcomp, dy=Len_32, dz=Wid_32, beta=beta32, alpha=alpha32)
  Reflector_Element12 [copper] = part_of(HFSSDesign1_12) in module32
  HFSSDesign1_13 = component(HFSSDesign1, 3D_Component_File_Path=C:/Users/vemana/Desktop/Modified_HELIOS_Footprint.a3dcomp, dy=Len_33, dz=Wid_33, beta=beta33, alpha=alpha33)
  Reflector_Element13 [copper] = part_of(HFSSDesign1_13) in module33
  HFSSDesign1_14 = component(HFSSDesign1, 3D_Component_File_Path=C:/Users/vemana/Desktop/Modified_HELIOS_Footprint.a3dcomp, dy=Len_34, dz=Wid_34, beta=beta34, alpha=alpha34)
  Reflector_Element14 [copper] = part_of(HFSSDesign1_14) in module34
  HFSSDesign1_15 = component(HFSSDesign1, 3D_Component_File_Path=C:/Users/vemana/Desktop/Modified_HELIOS_Footprint.a3dcomp, dy=Len_35, dz=Wid_35, beta=beta35, alpha=alpha35)
  Reflector_Element15 [copper] = part_of(HFSSDesign1_15) in module35
  HFSSDesign1_16 = component(HFSSDesign1, 3D_Component_File_Path=C:/Users/vemana/Desktop/Modified_HELIOS_Footprint.a3dcomp, dy=Len_41, dz=Wid_41, beta=beta41, alpha=alpha41)
  Reflector_Element16 [copper] = part_of(HFSSDesign1_16) in module41
  HFSSDesign1_17 = component(HFSSDesign1, 3D_Component_File_Path=C:/Users/vemana/Desktop/Modified_HELIOS_Footprint.a3dcomp, dy=Len_42, dz=Wid_42, beta=beta42, alpha=alpha42)
  Reflector_Element17 [copper] = part_of(HFSSDesign1_17) in module42
  HFSSDesign1_18 = component(HFSSDesign1, 3D_Component_File_Path=C:/Users/vemana/Desktop/Modified_HELIOS_Footprint.a3dcomp, dy=Len_43, dz=Wid_43, beta=beta43, alpha=alpha43)
  Reflector_Element18 [copper] = part_of(HFSSDesign1_18) in module43
  HFSSDesign1_19 = component(HFSSDesign1, 3D_Component_File_Path=C:/Users/vemana/Desktop/Modified_HELIOS_Footprint.a3dcomp, dy=Len_44, dz=Wid_44, beta=beta44, alpha=alpha44)
  Reflector_Element19 [copper] = part_of(HFSSDesign1_19) in module44
  HFSSDesign1_20 = component(HFSSDesign1, 3D_Component_File_Path=C:/Users/vemana/Desktop/Modified_HELIOS_Footprint.a3dcomp, dy=Len_45, dz=Wid_45, beta=beta45, alpha=alpha45)
  Reflector_Element20 [copper] = part_of(HFSSDesign1_20) in module45
  HFSSDesign1_21 = component(HFSSDesign1, 3D_Component_File_Path=C:/Users/vemana/Desktop/Modified_HELIOS_Footprint.a3dcomp, dy=Len_51, dz=Wid_51, beta=beta51, alpha=alpha51)
  Reflector_Element21 [copper] = part_of(HFSSDesign1_21) in module51
  HFSSDesign1_22 = component(HFSSDesign1, 3D_Component_File_Path=C:/Users/vemana/Desktop/Modified_HELIOS_Footprint.a3dcomp, dy=Len_52, dz=Wid_52, beta=beta52, alpha=alpha52)
  Reflector_Element22 [copper] = part_of(HFSSDesign1_22) in module52
  HFSSDesign1_23 = component(HFSSDesign1, 3D_Component_File_Path=C:/Users/vemana/Desktop/Modified_HELIOS_Footprint.a3dcomp, dy=Len_53, dz=Wid_53, beta=beta53, alpha=alpha53)
  Reflector_Element23 [copper] = part_of(HFSSDesign1_23) in module53
  HFSSDesign1_24 = component(HFSSDesign1, 3D_Component_File_Path=C:/Users/vemana/Desktop/Modified_HELIOS_Footprint.a3dcomp, dy=Len_54, dz=Wid_54, beta=beta54, alpha=alpha54)
  Reflector_Element24 [copper] = part_of(HFSSDesign1_24) in module54
  HFSSDesign1_25 = component(HFSSDesign1, 3D_Component_File_Path=C:/Users/vemana/Desktop/Modified_HELIOS_Footprint.a3dcomp, dy=Len_55, dz=Wid_55, beta=beta55, alpha=alpha55)
  Reflector_Element25 [copper] = part_of(HFSSDesign1_25) in module55
boundaries and excitations:
  HFSSDesign1_1_SBRRegion1: Hybrid Region Objects=Reflector_Element Type=SBR+
  HFSSDesign1_1_FiniteCond1: Finite Conductivity Objects=Reflector_Element UseMaterial Material=HFSSDesign1_1:copper IsInternal
  HFSSDesign1_2_SBRRegion1: Hybrid Region Objects=Reflector_Element2 Type=SBR+
  HFSSDesign1_2_FiniteCond1: Finite Conductivity Objects=Reflector_Element2 UseMaterial Material=HFSSDesign1_2:copper IsInternal
  HFSSDesign1_3_SBRRegion1: Hybrid Region Objects=Reflector_Element3 Type=SBR+
  HFSSDesign1_3_FiniteCond1: Finite Conductivity Objects=Reflector_Element3 UseMaterial Material=HFSSDesign1_3:copper IsInternal
  HFSSDesign1_4_SBRRegion1: Hybrid Region Objects=Reflector_Element4 Type=SBR+
  HFSSDesign1_4_FiniteCond1: Finite Conductivity Objects=Reflector_Element4 UseMaterial Material=HFSSDesign1_4:copper IsInternal
  HFSSDesign1_5_SBRRegion1: Hybrid Region Objects=Reflector_Element5 Type=SBR+
  HFSSDesign1_5_FiniteCond1: Finite Conductivity Objects=Reflector_Element5 UseMaterial Material=HFSSDesign1_5:copper IsInternal
  HFSSDesign1_6_SBRRegion1: Hybrid Region Objects=Reflector_Element6 Type=SBR+
  HFSSDesign1_6_FiniteCond1: Finite Conductivity Objects=Reflector_Element6 UseMaterial Material=HFSSDesign1_6:copper IsInternal
  HFSSDesign1_7_SBRRegion1: Hybrid Region Objects=Reflector_Element7 Type=SBR+
  HFSSDesign1_7_FiniteCond1: Finite Conductivity Objects=Reflector_Element7 UseMaterial Material=HFSSDesign1_7:copper IsInternal
  HFSSDesign1_8_SBRRegion1: Hybrid Region Objects=Reflector_Element8 Type=SBR+
  HFSSDesign1_8_FiniteCond1: Finite Conductivity Objects=Reflector_Element8 UseMaterial Material=HFSSDesign1_8:copper IsInternal
  HFSSDesign1_9_SBRRegion1: Hybrid Region Objects=Reflector_Element9 Type=SBR+
  HFSSDesign1_9_FiniteCond1: Finite Conductivity Objects=Reflector_Element9 UseMaterial Material=HFSSDesign1_9:copper IsInternal
  HFSSDesign1_10_SBRRegion1: Hybrid Region Objects=Reflector_Element10 Type=SBR+
  HFSSDesign1_10_FiniteCond1: Finite Conductivity Objects=Reflector_Element10 UseMaterial Material=HFSSDesign1_10:copper IsInternal
  HFSSDesign1_11_SBRRegion1: Hybrid Region Objects=Reflector_Element11 Type=SBR+
  HFSSDesign1_11_FiniteCond1: Finite Conductivity Objects=Reflector_Element11 UseMaterial Material=HFSSDesign1_11:copper IsInternal
  HFSSDesign1_12_SBRRegion1: Hybrid Region Objects=Reflector_Element12 Type=SBR+
  HFSSDesign1_12_FiniteCond1: Finite Conductivity Objects=Reflector_Element12 UseMaterial Material=HFSSDesign1_12:copper IsInternal
  HFSSDesign1_13_SBRRegion1: Hybrid Region Objects=Reflector_Element13 Type=SBR+
  HFSSDesign1_13_FiniteCond1: Finite Conductivity Objects=Reflector_Element13 UseMaterial Material=HFSSDesign1_13:copper IsInternal
  HFSSDesign1_14_SBRRegion1: Hybrid Region Objects=Reflector_Element14 Type=SBR+
  HFSSDesign1_14_FiniteCond1: Finite Conductivity Objects=Reflector_Element14 UseMaterial Material=HFSSDesign1_14:copper IsInternal
  HFSSDesign1_15_SBRRegion1: Hybrid Region Objects=Reflector_Element15 Type=SBR+
  HFSSDesign1_15_FiniteCond1: Finite Conductivity Objects=Reflector_Element15 UseMaterial Material=HFSSDesign1_15:copper IsInternal
  HFSSDesign1_16_SBRRegion1: Hybrid Region Objects=Reflector_Element16 Type=SBR+
  HFSSDesign1_16_FiniteCond1: Finite Conductivity Objects=Reflector_Element16 UseMaterial Material=HFSSDesign1_16:copper IsInternal
  HFSSDesign1_17_SBRRegion1: Hybrid Region Objects=Reflector_Element17 Type=SBR+
  HFSSDesign1_17_FiniteCond1: Finite Conductivity Objects=Reflector_Element17 UseMaterial Material=HFSSDesign1_17:copper IsInternal
  HFSSDesign1_18_SBRRegion1: Hybrid Region Objects=Reflector_Element18 Type=SBR+
  HFSSDesign1_18_FiniteCond1: Finite Conductivity Objects=Reflector_Element18 UseMaterial Material=HFSSDesign1_18:copper IsInternal
  HFSSDesign1_19_SBRRegion1: Hybrid Region Objects=Reflector_Element19 Type=SBR+
  HFSSDesign1_19_FiniteCond1: Finite Conductivity Objects=Reflector_Element19 UseMaterial Material=HFSSDesign1_19:copper IsInternal
  HFSSDesign1_20_SBRRegion1: Hybrid Region Objects=Reflector_Element20 Type=SBR+
  HFSSDesign1_20_FiniteCond1: Finite Conductivity Objects=Reflector_Element20 UseMaterial Material=HFSSDesign1_20:copper IsInternal
  HFSSDesign1_21_SBRRegion1: Hybrid Region Objects=Reflector_Element21 Type=SBR+
  HFSSDesign1_21_FiniteCond1: Finite Conductivity Objects=Reflector_Element21 UseMaterial Material=HFSSDesign1_21:copper IsInternal
  HFSSDesign1_22_SBRRegion1: Hybrid Region Objects=Reflector_Element22 Type=SBR+
  HFSSDesign1_22_FiniteCond1: Finite Conductivity Objects=Reflector_Element22 UseMaterial Material=HFSSDesign1_22:copper IsInternal
  HFSSDesign1_23_SBRRegion1: Hybrid Region Objects=Reflector_Element23 Type=SBR+
  HFSSDesign1_23_FiniteCond1: Finite Conductivity Objects=Reflector_Element23 UseMaterial Material=HFSSDesign1_23:copper IsInternal
  HFSSDesign1_24_SBRRegion1: Hybrid Region Objects=Reflector_Element24 Type=SBR+
  HFSSDesign1_24_FiniteCond1: Finite Conductivity Objects=Reflector_Element24 UseMaterial Material=HFSSDesign1_24:copper IsInternal
  HFSSDesign1_25_SBRRegion1: Hybrid Region Objects=Reflector_Element25 Type=SBR+
  HFSSDesign1_25_FiniteCond1: Finite Conductivity Objects=Reflector_Element25 UseMaterial Material=HFSSDesign1_25:copper IsInternal
  IncPWave1: Plane Incident Wave PhiStart="(180+az_angle*180/pi) deg" PhiStop="(180+az_angle*180/pi) deg" PhiPoints=1 ThetaStart="-el_angle*180/pi deg" ThetaStop="-el_angle*180/pi deg" ThetaPoints=1 EoPhi=1 EoTheta=0 OriginX=spacing_x OriginY=spacing_y OriginZ=spacing_z IsPropagating
mesh:
  HFSSDesign1_1_SBRCurvExtr1: CurvatureExtraction Objects=Reflector_Element DisableForFacetedSurfaces
  HFSSDesign1_2_SBRCurvExtr1: CurvatureExtraction Objects=Reflector_Element2 DisableForFacetedSurfaces
  HFSSDesign1_3_SBRCurvExtr1: CurvatureExtraction Objects=Reflector_Element3 DisableForFacetedSurfaces
  HFSSDesign1_4_SBRCurvExtr1: CurvatureExtraction Objects=Reflector_Element4 DisableForFacetedSurfaces
  HFSSDesign1_5_SBRCurvExtr1: CurvatureExtraction Objects=Reflector_Element5 DisableForFacetedSurfaces
  HFSSDesign1_6_SBRCurvExtr1: CurvatureExtraction Objects=Reflector_Element6 DisableForFacetedSurfaces
  HFSSDesign1_7_SBRCurvExtr1: CurvatureExtraction Objects=Reflector_Element7 DisableForFacetedSurfaces
  HFSSDesign1_8_SBRCurvExtr1: CurvatureExtraction Objects=Reflector_Element8 DisableForFacetedSurfaces
  HFSSDesign1_9_SBRCurvExtr1: CurvatureExtraction Objects=Reflector_Element9 DisableForFacetedSurfaces
  HFSSDesign1_10_SBRCurvExtr1: CurvatureExtraction Objects=Reflector_Element10 DisableForFacetedSurfaces
  HFSSDesign1_11_SBRCurvExtr1: CurvatureExtraction Objects=Reflector_Element11 DisableForFacetedSurfaces
  HFSSDesign1_12_SBRCurvExtr1: CurvatureExtraction Objects=Reflector_Element12 DisableForFacetedSurfaces
  HFSSDesign1_13_SBRCurvExtr1: CurvatureExtraction Objects=Reflector_Element13 DisableForFacetedSurfaces
  HFSSDesign1_14_SBRCurvExtr1: CurvatureExtraction Objects=Reflector_Element14 DisableForFacetedSurfaces
  HFSSDesign1_15_SBRCurvExtr1: CurvatureExtraction Objects=Reflector_Element15 DisableForFacetedSurfaces
  HFSSDesign1_16_SBRCurvExtr1: CurvatureExtraction Objects=Reflector_Element16 DisableForFacetedSurfaces
  HFSSDesign1_17_SBRCurvExtr1: CurvatureExtraction Objects=Reflector_Element17 DisableForFacetedSurfaces
  HFSSDesign1_18_SBRCurvExtr1: CurvatureExtraction Objects=Reflector_Element18 DisableForFacetedSurfaces
  HFSSDesign1_19_SBRCurvExtr1: CurvatureExtraction Objects=Reflector_Element19 DisableForFacetedSurfaces
  HFSSDesign1_20_SBRCurvExtr1: CurvatureExtraction Objects=Reflector_Element20 DisableForFacetedSurfaces
  HFSSDesign1_21_SBRCurvExtr1: CurvatureExtraction Objects=Reflector_Element21 DisableForFacetedSurfaces
  HFSSDesign1_22_SBRCurvExtr1: CurvatureExtraction Objects=Reflector_Element22 DisableForFacetedSurfaces
  HFSSDesign1_23_SBRCurvExtr1: CurvatureExtraction Objects=Reflector_Element23 DisableForFacetedSurfaces
  HFSSDesign1_24_SBRCurvExtr1: CurvatureExtraction Objects=Reflector_Element24 DisableForFacetedSurfaces
  HFSSDesign1_25_SBRCurvExtr1: CurvatureExtraction Objects=Reflector_Element25 DisableForFacetedSurfaces
setups:
  Setup1: HfssDriven RayDensityPerWavelength=4 MaxNumberOfBounces=5 RadiationSetup=72 PTDUTDSimulationSettings="PTD Correction + UTD Rays" PTDEdgeDensity=20 ComputeFarFields
    sweep Sweep: point 28GHz;
source amplitudes:
  IncPWave1:1: 1 0deg
radiation setups:
  FarField_Setup: Infinite Sphere Theta=0deg..180deg step 1deg Phi=-90deg..90deg step 1deg CoordSystem=module11
reports:
  FarField_Report: dB(RCSTotal) vs Phi, Theta on Setup1 : Sweep, FarField_Setup [Freq=28GHz IWavePhi=180deg IWaveTheta=-90deg]
